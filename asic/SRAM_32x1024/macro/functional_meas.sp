.meas tran vdout0_0ck40 FIND v(dout0_0) AT=50.05n

.meas tran vdout0_1ck40 FIND v(dout0_1) AT=50.05n

.meas tran vdout0_2ck40 FIND v(dout0_2) AT=50.05n

.meas tran vdout0_3ck40 FIND v(dout0_3) AT=50.05n

.meas tran vdout0_4ck40 FIND v(dout0_4) AT=50.05n

.meas tran vdout0_5ck40 FIND v(dout0_5) AT=50.05n

.meas tran vdout0_6ck40 FIND v(dout0_6) AT=50.05n

.meas tran vdout0_7ck40 FIND v(dout0_7) AT=50.05n

.meas tran vdout0_8ck40 FIND v(dout0_8) AT=50.05n

.meas tran vdout0_9ck40 FIND v(dout0_9) AT=50.05n

.meas tran vdout0_10ck40 FIND v(dout0_10) AT=50.05n

.meas tran vdout0_11ck40 FIND v(dout0_11) AT=50.05n

.meas tran vdout0_12ck40 FIND v(dout0_12) AT=50.05n

.meas tran vdout0_13ck40 FIND v(dout0_13) AT=50.05n

.meas tran vdout0_14ck40 FIND v(dout0_14) AT=50.05n

.meas tran vdout0_15ck40 FIND v(dout0_15) AT=50.05n

.meas tran vdout0_16ck40 FIND v(dout0_16) AT=50.05n

.meas tran vdout0_17ck40 FIND v(dout0_17) AT=50.05n

.meas tran vdout0_18ck40 FIND v(dout0_18) AT=50.05n

.meas tran vdout0_19ck40 FIND v(dout0_19) AT=50.05n

.meas tran vdout0_20ck40 FIND v(dout0_20) AT=50.05n

.meas tran vdout0_21ck40 FIND v(dout0_21) AT=50.05n

.meas tran vdout0_22ck40 FIND v(dout0_22) AT=50.05n

.meas tran vdout0_23ck40 FIND v(dout0_23) AT=50.05n

.meas tran vdout0_24ck40 FIND v(dout0_24) AT=50.05n

.meas tran vdout0_25ck40 FIND v(dout0_25) AT=50.05n

.meas tran vdout0_26ck40 FIND v(dout0_26) AT=50.05n

.meas tran vdout0_27ck40 FIND v(dout0_27) AT=50.05n

.meas tran vdout0_28ck40 FIND v(dout0_28) AT=50.05n

.meas tran vdout0_29ck40 FIND v(dout0_29) AT=50.05n

.meas tran vdout0_30ck40 FIND v(dout0_30) AT=50.05n

.meas tran vdout0_31ck40 FIND v(dout0_31) AT=50.05n

.meas tran vdout0_32ck40 FIND v(dout0_32) AT=50.05n

.meas tran vdout0_0ck60 FIND v(dout0_0) AT=70.05n

.meas tran vdout0_1ck60 FIND v(dout0_1) AT=70.05n

.meas tran vdout0_2ck60 FIND v(dout0_2) AT=70.05n

.meas tran vdout0_3ck60 FIND v(dout0_3) AT=70.05n

.meas tran vdout0_4ck60 FIND v(dout0_4) AT=70.05n

.meas tran vdout0_5ck60 FIND v(dout0_5) AT=70.05n

.meas tran vdout0_6ck60 FIND v(dout0_6) AT=70.05n

.meas tran vdout0_7ck60 FIND v(dout0_7) AT=70.05n

.meas tran vdout0_8ck60 FIND v(dout0_8) AT=70.05n

.meas tran vdout0_9ck60 FIND v(dout0_9) AT=70.05n

.meas tran vdout0_10ck60 FIND v(dout0_10) AT=70.05n

.meas tran vdout0_11ck60 FIND v(dout0_11) AT=70.05n

.meas tran vdout0_12ck60 FIND v(dout0_12) AT=70.05n

.meas tran vdout0_13ck60 FIND v(dout0_13) AT=70.05n

.meas tran vdout0_14ck60 FIND v(dout0_14) AT=70.05n

.meas tran vdout0_15ck60 FIND v(dout0_15) AT=70.05n

.meas tran vdout0_16ck60 FIND v(dout0_16) AT=70.05n

.meas tran vdout0_17ck60 FIND v(dout0_17) AT=70.05n

.meas tran vdout0_18ck60 FIND v(dout0_18) AT=70.05n

.meas tran vdout0_19ck60 FIND v(dout0_19) AT=70.05n

.meas tran vdout0_20ck60 FIND v(dout0_20) AT=70.05n

.meas tran vdout0_21ck60 FIND v(dout0_21) AT=70.05n

.meas tran vdout0_22ck60 FIND v(dout0_22) AT=70.05n

.meas tran vdout0_23ck60 FIND v(dout0_23) AT=70.05n

.meas tran vdout0_24ck60 FIND v(dout0_24) AT=70.05n

.meas tran vdout0_25ck60 FIND v(dout0_25) AT=70.05n

.meas tran vdout0_26ck60 FIND v(dout0_26) AT=70.05n

.meas tran vdout0_27ck60 FIND v(dout0_27) AT=70.05n

.meas tran vdout0_28ck60 FIND v(dout0_28) AT=70.05n

.meas tran vdout0_29ck60 FIND v(dout0_29) AT=70.05n

.meas tran vdout0_30ck60 FIND v(dout0_30) AT=70.05n

.meas tran vdout0_31ck60 FIND v(dout0_31) AT=70.05n

.meas tran vdout0_32ck60 FIND v(dout0_32) AT=70.05n

.meas tran vdout0_0ck140 FIND v(dout0_0) AT=150.05n

.meas tran vdout0_1ck140 FIND v(dout0_1) AT=150.05n

.meas tran vdout0_2ck140 FIND v(dout0_2) AT=150.05n

.meas tran vdout0_3ck140 FIND v(dout0_3) AT=150.05n

.meas tran vdout0_4ck140 FIND v(dout0_4) AT=150.05n

.meas tran vdout0_5ck140 FIND v(dout0_5) AT=150.05n

.meas tran vdout0_6ck140 FIND v(dout0_6) AT=150.05n

.meas tran vdout0_7ck140 FIND v(dout0_7) AT=150.05n

.meas tran vdout0_8ck140 FIND v(dout0_8) AT=150.05n

.meas tran vdout0_9ck140 FIND v(dout0_9) AT=150.05n

.meas tran vdout0_10ck140 FIND v(dout0_10) AT=150.05n

.meas tran vdout0_11ck140 FIND v(dout0_11) AT=150.05n

.meas tran vdout0_12ck140 FIND v(dout0_12) AT=150.05n

.meas tran vdout0_13ck140 FIND v(dout0_13) AT=150.05n

.meas tran vdout0_14ck140 FIND v(dout0_14) AT=150.05n

.meas tran vdout0_15ck140 FIND v(dout0_15) AT=150.05n

.meas tran vdout0_16ck140 FIND v(dout0_16) AT=150.05n

.meas tran vdout0_17ck140 FIND v(dout0_17) AT=150.05n

.meas tran vdout0_18ck140 FIND v(dout0_18) AT=150.05n

.meas tran vdout0_19ck140 FIND v(dout0_19) AT=150.05n

.meas tran vdout0_20ck140 FIND v(dout0_20) AT=150.05n

.meas tran vdout0_21ck140 FIND v(dout0_21) AT=150.05n

.meas tran vdout0_22ck140 FIND v(dout0_22) AT=150.05n

.meas tran vdout0_23ck140 FIND v(dout0_23) AT=150.05n

.meas tran vdout0_24ck140 FIND v(dout0_24) AT=150.05n

.meas tran vdout0_25ck140 FIND v(dout0_25) AT=150.05n

.meas tran vdout0_26ck140 FIND v(dout0_26) AT=150.05n

.meas tran vdout0_27ck140 FIND v(dout0_27) AT=150.05n

.meas tran vdout0_28ck140 FIND v(dout0_28) AT=150.05n

.meas tran vdout0_29ck140 FIND v(dout0_29) AT=150.05n

.meas tran vdout0_30ck140 FIND v(dout0_30) AT=150.05n

.meas tran vdout0_31ck140 FIND v(dout0_31) AT=150.05n

.meas tran vdout0_32ck140 FIND v(dout0_32) AT=150.05n

.meas tran vdout0_0ck170 FIND v(dout0_0) AT=180.05n

.meas tran vdout0_1ck170 FIND v(dout0_1) AT=180.05n

.meas tran vdout0_2ck170 FIND v(dout0_2) AT=180.05n

.meas tran vdout0_3ck170 FIND v(dout0_3) AT=180.05n

.meas tran vdout0_4ck170 FIND v(dout0_4) AT=180.05n

.meas tran vdout0_5ck170 FIND v(dout0_5) AT=180.05n

.meas tran vdout0_6ck170 FIND v(dout0_6) AT=180.05n

.meas tran vdout0_7ck170 FIND v(dout0_7) AT=180.05n

.meas tran vdout0_8ck170 FIND v(dout0_8) AT=180.05n

.meas tran vdout0_9ck170 FIND v(dout0_9) AT=180.05n

.meas tran vdout0_10ck170 FIND v(dout0_10) AT=180.05n

.meas tran vdout0_11ck170 FIND v(dout0_11) AT=180.05n

.meas tran vdout0_12ck170 FIND v(dout0_12) AT=180.05n

.meas tran vdout0_13ck170 FIND v(dout0_13) AT=180.05n

.meas tran vdout0_14ck170 FIND v(dout0_14) AT=180.05n

.meas tran vdout0_15ck170 FIND v(dout0_15) AT=180.05n

.meas tran vdout0_16ck170 FIND v(dout0_16) AT=180.05n

.meas tran vdout0_17ck170 FIND v(dout0_17) AT=180.05n

.meas tran vdout0_18ck170 FIND v(dout0_18) AT=180.05n

.meas tran vdout0_19ck170 FIND v(dout0_19) AT=180.05n

.meas tran vdout0_20ck170 FIND v(dout0_20) AT=180.05n

.meas tran vdout0_21ck170 FIND v(dout0_21) AT=180.05n

.meas tran vdout0_22ck170 FIND v(dout0_22) AT=180.05n

.meas tran vdout0_23ck170 FIND v(dout0_23) AT=180.05n

.meas tran vdout0_24ck170 FIND v(dout0_24) AT=180.05n

.meas tran vdout0_25ck170 FIND v(dout0_25) AT=180.05n

.meas tran vdout0_26ck170 FIND v(dout0_26) AT=180.05n

.meas tran vdout0_27ck170 FIND v(dout0_27) AT=180.05n

.meas tran vdout0_28ck170 FIND v(dout0_28) AT=180.05n

.meas tran vdout0_29ck170 FIND v(dout0_29) AT=180.05n

.meas tran vdout0_30ck170 FIND v(dout0_30) AT=180.05n

.meas tran vdout0_31ck170 FIND v(dout0_31) AT=180.05n

.meas tran vdout0_32ck170 FIND v(dout0_32) AT=180.05n

.meas tran vdout0_0ck190 FIND v(dout0_0) AT=200.05n

.meas tran vdout0_1ck190 FIND v(dout0_1) AT=200.05n

.meas tran vdout0_2ck190 FIND v(dout0_2) AT=200.05n

.meas tran vdout0_3ck190 FIND v(dout0_3) AT=200.05n

.meas tran vdout0_4ck190 FIND v(dout0_4) AT=200.05n

.meas tran vdout0_5ck190 FIND v(dout0_5) AT=200.05n

.meas tran vdout0_6ck190 FIND v(dout0_6) AT=200.05n

.meas tran vdout0_7ck190 FIND v(dout0_7) AT=200.05n

.meas tran vdout0_8ck190 FIND v(dout0_8) AT=200.05n

.meas tran vdout0_9ck190 FIND v(dout0_9) AT=200.05n

.meas tran vdout0_10ck190 FIND v(dout0_10) AT=200.05n

.meas tran vdout0_11ck190 FIND v(dout0_11) AT=200.05n

.meas tran vdout0_12ck190 FIND v(dout0_12) AT=200.05n

.meas tran vdout0_13ck190 FIND v(dout0_13) AT=200.05n

.meas tran vdout0_14ck190 FIND v(dout0_14) AT=200.05n

.meas tran vdout0_15ck190 FIND v(dout0_15) AT=200.05n

.meas tran vdout0_16ck190 FIND v(dout0_16) AT=200.05n

.meas tran vdout0_17ck190 FIND v(dout0_17) AT=200.05n

.meas tran vdout0_18ck190 FIND v(dout0_18) AT=200.05n

.meas tran vdout0_19ck190 FIND v(dout0_19) AT=200.05n

.meas tran vdout0_20ck190 FIND v(dout0_20) AT=200.05n

.meas tran vdout0_21ck190 FIND v(dout0_21) AT=200.05n

.meas tran vdout0_22ck190 FIND v(dout0_22) AT=200.05n

.meas tran vdout0_23ck190 FIND v(dout0_23) AT=200.05n

.meas tran vdout0_24ck190 FIND v(dout0_24) AT=200.05n

.meas tran vdout0_25ck190 FIND v(dout0_25) AT=200.05n

.meas tran vdout0_26ck190 FIND v(dout0_26) AT=200.05n

.meas tran vdout0_27ck190 FIND v(dout0_27) AT=200.05n

.meas tran vdout0_28ck190 FIND v(dout0_28) AT=200.05n

.meas tran vdout0_29ck190 FIND v(dout0_29) AT=200.05n

.meas tran vdout0_30ck190 FIND v(dout0_30) AT=200.05n

.meas tran vdout0_31ck190 FIND v(dout0_31) AT=200.05n

.meas tran vdout0_32ck190 FIND v(dout0_32) AT=200.05n

.meas tran vdout0_0ck230 FIND v(dout0_0) AT=240.05n

.meas tran vdout0_1ck230 FIND v(dout0_1) AT=240.05n

.meas tran vdout0_2ck230 FIND v(dout0_2) AT=240.05n

.meas tran vdout0_3ck230 FIND v(dout0_3) AT=240.05n

.meas tran vdout0_4ck230 FIND v(dout0_4) AT=240.05n

.meas tran vdout0_5ck230 FIND v(dout0_5) AT=240.05n

.meas tran vdout0_6ck230 FIND v(dout0_6) AT=240.05n

.meas tran vdout0_7ck230 FIND v(dout0_7) AT=240.05n

.meas tran vdout0_8ck230 FIND v(dout0_8) AT=240.05n

.meas tran vdout0_9ck230 FIND v(dout0_9) AT=240.05n

.meas tran vdout0_10ck230 FIND v(dout0_10) AT=240.05n

.meas tran vdout0_11ck230 FIND v(dout0_11) AT=240.05n

.meas tran vdout0_12ck230 FIND v(dout0_12) AT=240.05n

.meas tran vdout0_13ck230 FIND v(dout0_13) AT=240.05n

.meas tran vdout0_14ck230 FIND v(dout0_14) AT=240.05n

.meas tran vdout0_15ck230 FIND v(dout0_15) AT=240.05n

.meas tran vdout0_16ck230 FIND v(dout0_16) AT=240.05n

.meas tran vdout0_17ck230 FIND v(dout0_17) AT=240.05n

.meas tran vdout0_18ck230 FIND v(dout0_18) AT=240.05n

.meas tran vdout0_19ck230 FIND v(dout0_19) AT=240.05n

.meas tran vdout0_20ck230 FIND v(dout0_20) AT=240.05n

.meas tran vdout0_21ck230 FIND v(dout0_21) AT=240.05n

.meas tran vdout0_22ck230 FIND v(dout0_22) AT=240.05n

.meas tran vdout0_23ck230 FIND v(dout0_23) AT=240.05n

.meas tran vdout0_24ck230 FIND v(dout0_24) AT=240.05n

.meas tran vdout0_25ck230 FIND v(dout0_25) AT=240.05n

.meas tran vdout0_26ck230 FIND v(dout0_26) AT=240.05n

.meas tran vdout0_27ck230 FIND v(dout0_27) AT=240.05n

.meas tran vdout0_28ck230 FIND v(dout0_28) AT=240.05n

.meas tran vdout0_29ck230 FIND v(dout0_29) AT=240.05n

.meas tran vdout0_30ck230 FIND v(dout0_30) AT=240.05n

.meas tran vdout0_31ck230 FIND v(dout0_31) AT=240.05n

.meas tran vdout0_32ck230 FIND v(dout0_32) AT=240.05n

.meas tran vdout0_0ck250 FIND v(dout0_0) AT=260.05n

.meas tran vdout0_1ck250 FIND v(dout0_1) AT=260.05n

.meas tran vdout0_2ck250 FIND v(dout0_2) AT=260.05n

.meas tran vdout0_3ck250 FIND v(dout0_3) AT=260.05n

.meas tran vdout0_4ck250 FIND v(dout0_4) AT=260.05n

.meas tran vdout0_5ck250 FIND v(dout0_5) AT=260.05n

.meas tran vdout0_6ck250 FIND v(dout0_6) AT=260.05n

.meas tran vdout0_7ck250 FIND v(dout0_7) AT=260.05n

.meas tran vdout0_8ck250 FIND v(dout0_8) AT=260.05n

.meas tran vdout0_9ck250 FIND v(dout0_9) AT=260.05n

.meas tran vdout0_10ck250 FIND v(dout0_10) AT=260.05n

.meas tran vdout0_11ck250 FIND v(dout0_11) AT=260.05n

.meas tran vdout0_12ck250 FIND v(dout0_12) AT=260.05n

.meas tran vdout0_13ck250 FIND v(dout0_13) AT=260.05n

.meas tran vdout0_14ck250 FIND v(dout0_14) AT=260.05n

.meas tran vdout0_15ck250 FIND v(dout0_15) AT=260.05n

.meas tran vdout0_16ck250 FIND v(dout0_16) AT=260.05n

.meas tran vdout0_17ck250 FIND v(dout0_17) AT=260.05n

.meas tran vdout0_18ck250 FIND v(dout0_18) AT=260.05n

.meas tran vdout0_19ck250 FIND v(dout0_19) AT=260.05n

.meas tran vdout0_20ck250 FIND v(dout0_20) AT=260.05n

.meas tran vdout0_21ck250 FIND v(dout0_21) AT=260.05n

.meas tran vdout0_22ck250 FIND v(dout0_22) AT=260.05n

.meas tran vdout0_23ck250 FIND v(dout0_23) AT=260.05n

.meas tran vdout0_24ck250 FIND v(dout0_24) AT=260.05n

.meas tran vdout0_25ck250 FIND v(dout0_25) AT=260.05n

.meas tran vdout0_26ck250 FIND v(dout0_26) AT=260.05n

.meas tran vdout0_27ck250 FIND v(dout0_27) AT=260.05n

.meas tran vdout0_28ck250 FIND v(dout0_28) AT=260.05n

.meas tran vdout0_29ck250 FIND v(dout0_29) AT=260.05n

.meas tran vdout0_30ck250 FIND v(dout0_30) AT=260.05n

.meas tran vdout0_31ck250 FIND v(dout0_31) AT=260.05n

.meas tran vdout0_32ck250 FIND v(dout0_32) AT=260.05n

.meas tran vdout0_0ck270 FIND v(dout0_0) AT=280.05n

.meas tran vdout0_1ck270 FIND v(dout0_1) AT=280.05n

.meas tran vdout0_2ck270 FIND v(dout0_2) AT=280.05n

.meas tran vdout0_3ck270 FIND v(dout0_3) AT=280.05n

.meas tran vdout0_4ck270 FIND v(dout0_4) AT=280.05n

.meas tran vdout0_5ck270 FIND v(dout0_5) AT=280.05n

.meas tran vdout0_6ck270 FIND v(dout0_6) AT=280.05n

.meas tran vdout0_7ck270 FIND v(dout0_7) AT=280.05n

.meas tran vdout0_8ck270 FIND v(dout0_8) AT=280.05n

.meas tran vdout0_9ck270 FIND v(dout0_9) AT=280.05n

.meas tran vdout0_10ck270 FIND v(dout0_10) AT=280.05n

.meas tran vdout0_11ck270 FIND v(dout0_11) AT=280.05n

.meas tran vdout0_12ck270 FIND v(dout0_12) AT=280.05n

.meas tran vdout0_13ck270 FIND v(dout0_13) AT=280.05n

.meas tran vdout0_14ck270 FIND v(dout0_14) AT=280.05n

.meas tran vdout0_15ck270 FIND v(dout0_15) AT=280.05n

.meas tran vdout0_16ck270 FIND v(dout0_16) AT=280.05n

.meas tran vdout0_17ck270 FIND v(dout0_17) AT=280.05n

.meas tran vdout0_18ck270 FIND v(dout0_18) AT=280.05n

.meas tran vdout0_19ck270 FIND v(dout0_19) AT=280.05n

.meas tran vdout0_20ck270 FIND v(dout0_20) AT=280.05n

.meas tran vdout0_21ck270 FIND v(dout0_21) AT=280.05n

.meas tran vdout0_22ck270 FIND v(dout0_22) AT=280.05n

.meas tran vdout0_23ck270 FIND v(dout0_23) AT=280.05n

.meas tran vdout0_24ck270 FIND v(dout0_24) AT=280.05n

.meas tran vdout0_25ck270 FIND v(dout0_25) AT=280.05n

.meas tran vdout0_26ck270 FIND v(dout0_26) AT=280.05n

.meas tran vdout0_27ck270 FIND v(dout0_27) AT=280.05n

.meas tran vdout0_28ck270 FIND v(dout0_28) AT=280.05n

.meas tran vdout0_29ck270 FIND v(dout0_29) AT=280.05n

.meas tran vdout0_30ck270 FIND v(dout0_30) AT=280.05n

.meas tran vdout0_31ck270 FIND v(dout0_31) AT=280.05n

.meas tran vdout0_32ck270 FIND v(dout0_32) AT=280.05n

.meas tran vdout0_0ck280 FIND v(dout0_0) AT=290.05n

.meas tran vdout0_1ck280 FIND v(dout0_1) AT=290.05n

.meas tran vdout0_2ck280 FIND v(dout0_2) AT=290.05n

.meas tran vdout0_3ck280 FIND v(dout0_3) AT=290.05n

.meas tran vdout0_4ck280 FIND v(dout0_4) AT=290.05n

.meas tran vdout0_5ck280 FIND v(dout0_5) AT=290.05n

.meas tran vdout0_6ck280 FIND v(dout0_6) AT=290.05n

.meas tran vdout0_7ck280 FIND v(dout0_7) AT=290.05n

.meas tran vdout0_8ck280 FIND v(dout0_8) AT=290.05n

.meas tran vdout0_9ck280 FIND v(dout0_9) AT=290.05n

.meas tran vdout0_10ck280 FIND v(dout0_10) AT=290.05n

.meas tran vdout0_11ck280 FIND v(dout0_11) AT=290.05n

.meas tran vdout0_12ck280 FIND v(dout0_12) AT=290.05n

.meas tran vdout0_13ck280 FIND v(dout0_13) AT=290.05n

.meas tran vdout0_14ck280 FIND v(dout0_14) AT=290.05n

.meas tran vdout0_15ck280 FIND v(dout0_15) AT=290.05n

.meas tran vdout0_16ck280 FIND v(dout0_16) AT=290.05n

.meas tran vdout0_17ck280 FIND v(dout0_17) AT=290.05n

.meas tran vdout0_18ck280 FIND v(dout0_18) AT=290.05n

.meas tran vdout0_19ck280 FIND v(dout0_19) AT=290.05n

.meas tran vdout0_20ck280 FIND v(dout0_20) AT=290.05n

.meas tran vdout0_21ck280 FIND v(dout0_21) AT=290.05n

.meas tran vdout0_22ck280 FIND v(dout0_22) AT=290.05n

.meas tran vdout0_23ck280 FIND v(dout0_23) AT=290.05n

.meas tran vdout0_24ck280 FIND v(dout0_24) AT=290.05n

.meas tran vdout0_25ck280 FIND v(dout0_25) AT=290.05n

.meas tran vdout0_26ck280 FIND v(dout0_26) AT=290.05n

.meas tran vdout0_27ck280 FIND v(dout0_27) AT=290.05n

.meas tran vdout0_28ck280 FIND v(dout0_28) AT=290.05n

.meas tran vdout0_29ck280 FIND v(dout0_29) AT=290.05n

.meas tran vdout0_30ck280 FIND v(dout0_30) AT=290.05n

.meas tran vdout0_31ck280 FIND v(dout0_31) AT=290.05n

.meas tran vdout0_32ck280 FIND v(dout0_32) AT=290.05n

.meas tran vdout0_0ck290 FIND v(dout0_0) AT=300.05n

.meas tran vdout0_1ck290 FIND v(dout0_1) AT=300.05n

.meas tran vdout0_2ck290 FIND v(dout0_2) AT=300.05n

.meas tran vdout0_3ck290 FIND v(dout0_3) AT=300.05n

.meas tran vdout0_4ck290 FIND v(dout0_4) AT=300.05n

.meas tran vdout0_5ck290 FIND v(dout0_5) AT=300.05n

.meas tran vdout0_6ck290 FIND v(dout0_6) AT=300.05n

.meas tran vdout0_7ck290 FIND v(dout0_7) AT=300.05n

.meas tran vdout0_8ck290 FIND v(dout0_8) AT=300.05n

.meas tran vdout0_9ck290 FIND v(dout0_9) AT=300.05n

.meas tran vdout0_10ck290 FIND v(dout0_10) AT=300.05n

.meas tran vdout0_11ck290 FIND v(dout0_11) AT=300.05n

.meas tran vdout0_12ck290 FIND v(dout0_12) AT=300.05n

.meas tran vdout0_13ck290 FIND v(dout0_13) AT=300.05n

.meas tran vdout0_14ck290 FIND v(dout0_14) AT=300.05n

.meas tran vdout0_15ck290 FIND v(dout0_15) AT=300.05n

.meas tran vdout0_16ck290 FIND v(dout0_16) AT=300.05n

.meas tran vdout0_17ck290 FIND v(dout0_17) AT=300.05n

.meas tran vdout0_18ck290 FIND v(dout0_18) AT=300.05n

.meas tran vdout0_19ck290 FIND v(dout0_19) AT=300.05n

.meas tran vdout0_20ck290 FIND v(dout0_20) AT=300.05n

.meas tran vdout0_21ck290 FIND v(dout0_21) AT=300.05n

.meas tran vdout0_22ck290 FIND v(dout0_22) AT=300.05n

.meas tran vdout0_23ck290 FIND v(dout0_23) AT=300.05n

.meas tran vdout0_24ck290 FIND v(dout0_24) AT=300.05n

.meas tran vdout0_25ck290 FIND v(dout0_25) AT=300.05n

.meas tran vdout0_26ck290 FIND v(dout0_26) AT=300.05n

.meas tran vdout0_27ck290 FIND v(dout0_27) AT=300.05n

.meas tran vdout0_28ck290 FIND v(dout0_28) AT=300.05n

.meas tran vdout0_29ck290 FIND v(dout0_29) AT=300.05n

.meas tran vdout0_30ck290 FIND v(dout0_30) AT=300.05n

.meas tran vdout0_31ck290 FIND v(dout0_31) AT=300.05n

.meas tran vdout0_32ck290 FIND v(dout0_32) AT=300.05n

.meas tran vdout0_0ck320 FIND v(dout0_0) AT=330.05n

.meas tran vdout0_1ck320 FIND v(dout0_1) AT=330.05n

.meas tran vdout0_2ck320 FIND v(dout0_2) AT=330.05n

.meas tran vdout0_3ck320 FIND v(dout0_3) AT=330.05n

.meas tran vdout0_4ck320 FIND v(dout0_4) AT=330.05n

.meas tran vdout0_5ck320 FIND v(dout0_5) AT=330.05n

.meas tran vdout0_6ck320 FIND v(dout0_6) AT=330.05n

.meas tran vdout0_7ck320 FIND v(dout0_7) AT=330.05n

.meas tran vdout0_8ck320 FIND v(dout0_8) AT=330.05n

.meas tran vdout0_9ck320 FIND v(dout0_9) AT=330.05n

.meas tran vdout0_10ck320 FIND v(dout0_10) AT=330.05n

.meas tran vdout0_11ck320 FIND v(dout0_11) AT=330.05n

.meas tran vdout0_12ck320 FIND v(dout0_12) AT=330.05n

.meas tran vdout0_13ck320 FIND v(dout0_13) AT=330.05n

.meas tran vdout0_14ck320 FIND v(dout0_14) AT=330.05n

.meas tran vdout0_15ck320 FIND v(dout0_15) AT=330.05n

.meas tran vdout0_16ck320 FIND v(dout0_16) AT=330.05n

.meas tran vdout0_17ck320 FIND v(dout0_17) AT=330.05n

.meas tran vdout0_18ck320 FIND v(dout0_18) AT=330.05n

.meas tran vdout0_19ck320 FIND v(dout0_19) AT=330.05n

.meas tran vdout0_20ck320 FIND v(dout0_20) AT=330.05n

.meas tran vdout0_21ck320 FIND v(dout0_21) AT=330.05n

.meas tran vdout0_22ck320 FIND v(dout0_22) AT=330.05n

.meas tran vdout0_23ck320 FIND v(dout0_23) AT=330.05n

.meas tran vdout0_24ck320 FIND v(dout0_24) AT=330.05n

.meas tran vdout0_25ck320 FIND v(dout0_25) AT=330.05n

.meas tran vdout0_26ck320 FIND v(dout0_26) AT=330.05n

.meas tran vdout0_27ck320 FIND v(dout0_27) AT=330.05n

.meas tran vdout0_28ck320 FIND v(dout0_28) AT=330.05n

.meas tran vdout0_29ck320 FIND v(dout0_29) AT=330.05n

.meas tran vdout0_30ck320 FIND v(dout0_30) AT=330.05n

.meas tran vdout0_31ck320 FIND v(dout0_31) AT=330.05n

.meas tran vdout0_32ck320 FIND v(dout0_32) AT=330.05n

.meas tran vdout0_0ck360 FIND v(dout0_0) AT=370.05n

.meas tran vdout0_1ck360 FIND v(dout0_1) AT=370.05n

.meas tran vdout0_2ck360 FIND v(dout0_2) AT=370.05n

.meas tran vdout0_3ck360 FIND v(dout0_3) AT=370.05n

.meas tran vdout0_4ck360 FIND v(dout0_4) AT=370.05n

.meas tran vdout0_5ck360 FIND v(dout0_5) AT=370.05n

.meas tran vdout0_6ck360 FIND v(dout0_6) AT=370.05n

.meas tran vdout0_7ck360 FIND v(dout0_7) AT=370.05n

.meas tran vdout0_8ck360 FIND v(dout0_8) AT=370.05n

.meas tran vdout0_9ck360 FIND v(dout0_9) AT=370.05n

.meas tran vdout0_10ck360 FIND v(dout0_10) AT=370.05n

.meas tran vdout0_11ck360 FIND v(dout0_11) AT=370.05n

.meas tran vdout0_12ck360 FIND v(dout0_12) AT=370.05n

.meas tran vdout0_13ck360 FIND v(dout0_13) AT=370.05n

.meas tran vdout0_14ck360 FIND v(dout0_14) AT=370.05n

.meas tran vdout0_15ck360 FIND v(dout0_15) AT=370.05n

.meas tran vdout0_16ck360 FIND v(dout0_16) AT=370.05n

.meas tran vdout0_17ck360 FIND v(dout0_17) AT=370.05n

.meas tran vdout0_18ck360 FIND v(dout0_18) AT=370.05n

.meas tran vdout0_19ck360 FIND v(dout0_19) AT=370.05n

.meas tran vdout0_20ck360 FIND v(dout0_20) AT=370.05n

.meas tran vdout0_21ck360 FIND v(dout0_21) AT=370.05n

.meas tran vdout0_22ck360 FIND v(dout0_22) AT=370.05n

.meas tran vdout0_23ck360 FIND v(dout0_23) AT=370.05n

.meas tran vdout0_24ck360 FIND v(dout0_24) AT=370.05n

.meas tran vdout0_25ck360 FIND v(dout0_25) AT=370.05n

.meas tran vdout0_26ck360 FIND v(dout0_26) AT=370.05n

.meas tran vdout0_27ck360 FIND v(dout0_27) AT=370.05n

.meas tran vdout0_28ck360 FIND v(dout0_28) AT=370.05n

.meas tran vdout0_29ck360 FIND v(dout0_29) AT=370.05n

.meas tran vdout0_30ck360 FIND v(dout0_30) AT=370.05n

.meas tran vdout0_31ck360 FIND v(dout0_31) AT=370.05n

.meas tran vdout0_32ck360 FIND v(dout0_32) AT=370.05n

.meas tran vdout0_0ck420 FIND v(dout0_0) AT=430.05n

.meas tran vdout0_1ck420 FIND v(dout0_1) AT=430.05n

.meas tran vdout0_2ck420 FIND v(dout0_2) AT=430.05n

.meas tran vdout0_3ck420 FIND v(dout0_3) AT=430.05n

.meas tran vdout0_4ck420 FIND v(dout0_4) AT=430.05n

.meas tran vdout0_5ck420 FIND v(dout0_5) AT=430.05n

.meas tran vdout0_6ck420 FIND v(dout0_6) AT=430.05n

.meas tran vdout0_7ck420 FIND v(dout0_7) AT=430.05n

.meas tran vdout0_8ck420 FIND v(dout0_8) AT=430.05n

.meas tran vdout0_9ck420 FIND v(dout0_9) AT=430.05n

.meas tran vdout0_10ck420 FIND v(dout0_10) AT=430.05n

.meas tran vdout0_11ck420 FIND v(dout0_11) AT=430.05n

.meas tran vdout0_12ck420 FIND v(dout0_12) AT=430.05n

.meas tran vdout0_13ck420 FIND v(dout0_13) AT=430.05n

.meas tran vdout0_14ck420 FIND v(dout0_14) AT=430.05n

.meas tran vdout0_15ck420 FIND v(dout0_15) AT=430.05n

.meas tran vdout0_16ck420 FIND v(dout0_16) AT=430.05n

.meas tran vdout0_17ck420 FIND v(dout0_17) AT=430.05n

.meas tran vdout0_18ck420 FIND v(dout0_18) AT=430.05n

.meas tran vdout0_19ck420 FIND v(dout0_19) AT=430.05n

.meas tran vdout0_20ck420 FIND v(dout0_20) AT=430.05n

.meas tran vdout0_21ck420 FIND v(dout0_21) AT=430.05n

.meas tran vdout0_22ck420 FIND v(dout0_22) AT=430.05n

.meas tran vdout0_23ck420 FIND v(dout0_23) AT=430.05n

.meas tran vdout0_24ck420 FIND v(dout0_24) AT=430.05n

.meas tran vdout0_25ck420 FIND v(dout0_25) AT=430.05n

.meas tran vdout0_26ck420 FIND v(dout0_26) AT=430.05n

.meas tran vdout0_27ck420 FIND v(dout0_27) AT=430.05n

.meas tran vdout0_28ck420 FIND v(dout0_28) AT=430.05n

.meas tran vdout0_29ck420 FIND v(dout0_29) AT=430.05n

.meas tran vdout0_30ck420 FIND v(dout0_30) AT=430.05n

.meas tran vdout0_31ck420 FIND v(dout0_31) AT=430.05n

.meas tran vdout0_32ck420 FIND v(dout0_32) AT=430.05n

.meas tran vdout0_0ck450 FIND v(dout0_0) AT=460.05n

.meas tran vdout0_1ck450 FIND v(dout0_1) AT=460.05n

.meas tran vdout0_2ck450 FIND v(dout0_2) AT=460.05n

.meas tran vdout0_3ck450 FIND v(dout0_3) AT=460.05n

.meas tran vdout0_4ck450 FIND v(dout0_4) AT=460.05n

.meas tran vdout0_5ck450 FIND v(dout0_5) AT=460.05n

.meas tran vdout0_6ck450 FIND v(dout0_6) AT=460.05n

.meas tran vdout0_7ck450 FIND v(dout0_7) AT=460.05n

.meas tran vdout0_8ck450 FIND v(dout0_8) AT=460.05n

.meas tran vdout0_9ck450 FIND v(dout0_9) AT=460.05n

.meas tran vdout0_10ck450 FIND v(dout0_10) AT=460.05n

.meas tran vdout0_11ck450 FIND v(dout0_11) AT=460.05n

.meas tran vdout0_12ck450 FIND v(dout0_12) AT=460.05n

.meas tran vdout0_13ck450 FIND v(dout0_13) AT=460.05n

.meas tran vdout0_14ck450 FIND v(dout0_14) AT=460.05n

.meas tran vdout0_15ck450 FIND v(dout0_15) AT=460.05n

.meas tran vdout0_16ck450 FIND v(dout0_16) AT=460.05n

.meas tran vdout0_17ck450 FIND v(dout0_17) AT=460.05n

.meas tran vdout0_18ck450 FIND v(dout0_18) AT=460.05n

.meas tran vdout0_19ck450 FIND v(dout0_19) AT=460.05n

.meas tran vdout0_20ck450 FIND v(dout0_20) AT=460.05n

.meas tran vdout0_21ck450 FIND v(dout0_21) AT=460.05n

.meas tran vdout0_22ck450 FIND v(dout0_22) AT=460.05n

.meas tran vdout0_23ck450 FIND v(dout0_23) AT=460.05n

.meas tran vdout0_24ck450 FIND v(dout0_24) AT=460.05n

.meas tran vdout0_25ck450 FIND v(dout0_25) AT=460.05n

.meas tran vdout0_26ck450 FIND v(dout0_26) AT=460.05n

.meas tran vdout0_27ck450 FIND v(dout0_27) AT=460.05n

.meas tran vdout0_28ck450 FIND v(dout0_28) AT=460.05n

.meas tran vdout0_29ck450 FIND v(dout0_29) AT=460.05n

.meas tran vdout0_30ck450 FIND v(dout0_30) AT=460.05n

.meas tran vdout0_31ck450 FIND v(dout0_31) AT=460.05n

.meas tran vdout0_32ck450 FIND v(dout0_32) AT=460.05n

.meas tran vdout0_0ck460 FIND v(dout0_0) AT=470.05n

.meas tran vdout0_1ck460 FIND v(dout0_1) AT=470.05n

.meas tran vdout0_2ck460 FIND v(dout0_2) AT=470.05n

.meas tran vdout0_3ck460 FIND v(dout0_3) AT=470.05n

.meas tran vdout0_4ck460 FIND v(dout0_4) AT=470.05n

.meas tran vdout0_5ck460 FIND v(dout0_5) AT=470.05n

.meas tran vdout0_6ck460 FIND v(dout0_6) AT=470.05n

.meas tran vdout0_7ck460 FIND v(dout0_7) AT=470.05n

.meas tran vdout0_8ck460 FIND v(dout0_8) AT=470.05n

.meas tran vdout0_9ck460 FIND v(dout0_9) AT=470.05n

.meas tran vdout0_10ck460 FIND v(dout0_10) AT=470.05n

.meas tran vdout0_11ck460 FIND v(dout0_11) AT=470.05n

.meas tran vdout0_12ck460 FIND v(dout0_12) AT=470.05n

.meas tran vdout0_13ck460 FIND v(dout0_13) AT=470.05n

.meas tran vdout0_14ck460 FIND v(dout0_14) AT=470.05n

.meas tran vdout0_15ck460 FIND v(dout0_15) AT=470.05n

.meas tran vdout0_16ck460 FIND v(dout0_16) AT=470.05n

.meas tran vdout0_17ck460 FIND v(dout0_17) AT=470.05n

.meas tran vdout0_18ck460 FIND v(dout0_18) AT=470.05n

.meas tran vdout0_19ck460 FIND v(dout0_19) AT=470.05n

.meas tran vdout0_20ck460 FIND v(dout0_20) AT=470.05n

.meas tran vdout0_21ck460 FIND v(dout0_21) AT=470.05n

.meas tran vdout0_22ck460 FIND v(dout0_22) AT=470.05n

.meas tran vdout0_23ck460 FIND v(dout0_23) AT=470.05n

.meas tran vdout0_24ck460 FIND v(dout0_24) AT=470.05n

.meas tran vdout0_25ck460 FIND v(dout0_25) AT=470.05n

.meas tran vdout0_26ck460 FIND v(dout0_26) AT=470.05n

.meas tran vdout0_27ck460 FIND v(dout0_27) AT=470.05n

.meas tran vdout0_28ck460 FIND v(dout0_28) AT=470.05n

.meas tran vdout0_29ck460 FIND v(dout0_29) AT=470.05n

.meas tran vdout0_30ck460 FIND v(dout0_30) AT=470.05n

.meas tran vdout0_31ck460 FIND v(dout0_31) AT=470.05n

.meas tran vdout0_32ck460 FIND v(dout0_32) AT=470.05n

.meas tran vdout0_0ck470 FIND v(dout0_0) AT=480.05n

.meas tran vdout0_1ck470 FIND v(dout0_1) AT=480.05n

.meas tran vdout0_2ck470 FIND v(dout0_2) AT=480.05n

.meas tran vdout0_3ck470 FIND v(dout0_3) AT=480.05n

.meas tran vdout0_4ck470 FIND v(dout0_4) AT=480.05n

.meas tran vdout0_5ck470 FIND v(dout0_5) AT=480.05n

.meas tran vdout0_6ck470 FIND v(dout0_6) AT=480.05n

.meas tran vdout0_7ck470 FIND v(dout0_7) AT=480.05n

.meas tran vdout0_8ck470 FIND v(dout0_8) AT=480.05n

.meas tran vdout0_9ck470 FIND v(dout0_9) AT=480.05n

.meas tran vdout0_10ck470 FIND v(dout0_10) AT=480.05n

.meas tran vdout0_11ck470 FIND v(dout0_11) AT=480.05n

.meas tran vdout0_12ck470 FIND v(dout0_12) AT=480.05n

.meas tran vdout0_13ck470 FIND v(dout0_13) AT=480.05n

.meas tran vdout0_14ck470 FIND v(dout0_14) AT=480.05n

.meas tran vdout0_15ck470 FIND v(dout0_15) AT=480.05n

.meas tran vdout0_16ck470 FIND v(dout0_16) AT=480.05n

.meas tran vdout0_17ck470 FIND v(dout0_17) AT=480.05n

.meas tran vdout0_18ck470 FIND v(dout0_18) AT=480.05n

.meas tran vdout0_19ck470 FIND v(dout0_19) AT=480.05n

.meas tran vdout0_20ck470 FIND v(dout0_20) AT=480.05n

.meas tran vdout0_21ck470 FIND v(dout0_21) AT=480.05n

.meas tran vdout0_22ck470 FIND v(dout0_22) AT=480.05n

.meas tran vdout0_23ck470 FIND v(dout0_23) AT=480.05n

.meas tran vdout0_24ck470 FIND v(dout0_24) AT=480.05n

.meas tran vdout0_25ck470 FIND v(dout0_25) AT=480.05n

.meas tran vdout0_26ck470 FIND v(dout0_26) AT=480.05n

.meas tran vdout0_27ck470 FIND v(dout0_27) AT=480.05n

.meas tran vdout0_28ck470 FIND v(dout0_28) AT=480.05n

.meas tran vdout0_29ck470 FIND v(dout0_29) AT=480.05n

.meas tran vdout0_30ck470 FIND v(dout0_30) AT=480.05n

.meas tran vdout0_31ck470 FIND v(dout0_31) AT=480.05n

.meas tran vdout0_32ck470 FIND v(dout0_32) AT=480.05n

.meas tran vdout0_0ck490 FIND v(dout0_0) AT=500.05n

.meas tran vdout0_1ck490 FIND v(dout0_1) AT=500.05n

.meas tran vdout0_2ck490 FIND v(dout0_2) AT=500.05n

.meas tran vdout0_3ck490 FIND v(dout0_3) AT=500.05n

.meas tran vdout0_4ck490 FIND v(dout0_4) AT=500.05n

.meas tran vdout0_5ck490 FIND v(dout0_5) AT=500.05n

.meas tran vdout0_6ck490 FIND v(dout0_6) AT=500.05n

.meas tran vdout0_7ck490 FIND v(dout0_7) AT=500.05n

.meas tran vdout0_8ck490 FIND v(dout0_8) AT=500.05n

.meas tran vdout0_9ck490 FIND v(dout0_9) AT=500.05n

.meas tran vdout0_10ck490 FIND v(dout0_10) AT=500.05n

.meas tran vdout0_11ck490 FIND v(dout0_11) AT=500.05n

.meas tran vdout0_12ck490 FIND v(dout0_12) AT=500.05n

.meas tran vdout0_13ck490 FIND v(dout0_13) AT=500.05n

.meas tran vdout0_14ck490 FIND v(dout0_14) AT=500.05n

.meas tran vdout0_15ck490 FIND v(dout0_15) AT=500.05n

.meas tran vdout0_16ck490 FIND v(dout0_16) AT=500.05n

.meas tran vdout0_17ck490 FIND v(dout0_17) AT=500.05n

.meas tran vdout0_18ck490 FIND v(dout0_18) AT=500.05n

.meas tran vdout0_19ck490 FIND v(dout0_19) AT=500.05n

.meas tran vdout0_20ck490 FIND v(dout0_20) AT=500.05n

.meas tran vdout0_21ck490 FIND v(dout0_21) AT=500.05n

.meas tran vdout0_22ck490 FIND v(dout0_22) AT=500.05n

.meas tran vdout0_23ck490 FIND v(dout0_23) AT=500.05n

.meas tran vdout0_24ck490 FIND v(dout0_24) AT=500.05n

.meas tran vdout0_25ck490 FIND v(dout0_25) AT=500.05n

.meas tran vdout0_26ck490 FIND v(dout0_26) AT=500.05n

.meas tran vdout0_27ck490 FIND v(dout0_27) AT=500.05n

.meas tran vdout0_28ck490 FIND v(dout0_28) AT=500.05n

.meas tran vdout0_29ck490 FIND v(dout0_29) AT=500.05n

.meas tran vdout0_30ck490 FIND v(dout0_30) AT=500.05n

.meas tran vdout0_31ck490 FIND v(dout0_31) AT=500.05n

.meas tran vdout0_32ck490 FIND v(dout0_32) AT=500.05n

.meas tran vdout0_0ck510 FIND v(dout0_0) AT=520.05n

.meas tran vdout0_1ck510 FIND v(dout0_1) AT=520.05n

.meas tran vdout0_2ck510 FIND v(dout0_2) AT=520.05n

.meas tran vdout0_3ck510 FIND v(dout0_3) AT=520.05n

.meas tran vdout0_4ck510 FIND v(dout0_4) AT=520.05n

.meas tran vdout0_5ck510 FIND v(dout0_5) AT=520.05n

.meas tran vdout0_6ck510 FIND v(dout0_6) AT=520.05n

.meas tran vdout0_7ck510 FIND v(dout0_7) AT=520.05n

.meas tran vdout0_8ck510 FIND v(dout0_8) AT=520.05n

.meas tran vdout0_9ck510 FIND v(dout0_9) AT=520.05n

.meas tran vdout0_10ck510 FIND v(dout0_10) AT=520.05n

.meas tran vdout0_11ck510 FIND v(dout0_11) AT=520.05n

.meas tran vdout0_12ck510 FIND v(dout0_12) AT=520.05n

.meas tran vdout0_13ck510 FIND v(dout0_13) AT=520.05n

.meas tran vdout0_14ck510 FIND v(dout0_14) AT=520.05n

.meas tran vdout0_15ck510 FIND v(dout0_15) AT=520.05n

.meas tran vdout0_16ck510 FIND v(dout0_16) AT=520.05n

.meas tran vdout0_17ck510 FIND v(dout0_17) AT=520.05n

.meas tran vdout0_18ck510 FIND v(dout0_18) AT=520.05n

.meas tran vdout0_19ck510 FIND v(dout0_19) AT=520.05n

.meas tran vdout0_20ck510 FIND v(dout0_20) AT=520.05n

.meas tran vdout0_21ck510 FIND v(dout0_21) AT=520.05n

.meas tran vdout0_22ck510 FIND v(dout0_22) AT=520.05n

.meas tran vdout0_23ck510 FIND v(dout0_23) AT=520.05n

.meas tran vdout0_24ck510 FIND v(dout0_24) AT=520.05n

.meas tran vdout0_25ck510 FIND v(dout0_25) AT=520.05n

.meas tran vdout0_26ck510 FIND v(dout0_26) AT=520.05n

.meas tran vdout0_27ck510 FIND v(dout0_27) AT=520.05n

.meas tran vdout0_28ck510 FIND v(dout0_28) AT=520.05n

.meas tran vdout0_29ck510 FIND v(dout0_29) AT=520.05n

.meas tran vdout0_30ck510 FIND v(dout0_30) AT=520.05n

.meas tran vdout0_31ck510 FIND v(dout0_31) AT=520.05n

.meas tran vdout0_32ck510 FIND v(dout0_32) AT=520.05n

.meas tran vdout0_0ck530 FIND v(dout0_0) AT=540.05n

.meas tran vdout0_1ck530 FIND v(dout0_1) AT=540.05n

.meas tran vdout0_2ck530 FIND v(dout0_2) AT=540.05n

.meas tran vdout0_3ck530 FIND v(dout0_3) AT=540.05n

.meas tran vdout0_4ck530 FIND v(dout0_4) AT=540.05n

.meas tran vdout0_5ck530 FIND v(dout0_5) AT=540.05n

.meas tran vdout0_6ck530 FIND v(dout0_6) AT=540.05n

.meas tran vdout0_7ck530 FIND v(dout0_7) AT=540.05n

.meas tran vdout0_8ck530 FIND v(dout0_8) AT=540.05n

.meas tran vdout0_9ck530 FIND v(dout0_9) AT=540.05n

.meas tran vdout0_10ck530 FIND v(dout0_10) AT=540.05n

.meas tran vdout0_11ck530 FIND v(dout0_11) AT=540.05n

.meas tran vdout0_12ck530 FIND v(dout0_12) AT=540.05n

.meas tran vdout0_13ck530 FIND v(dout0_13) AT=540.05n

.meas tran vdout0_14ck530 FIND v(dout0_14) AT=540.05n

.meas tran vdout0_15ck530 FIND v(dout0_15) AT=540.05n

.meas tran vdout0_16ck530 FIND v(dout0_16) AT=540.05n

.meas tran vdout0_17ck530 FIND v(dout0_17) AT=540.05n

.meas tran vdout0_18ck530 FIND v(dout0_18) AT=540.05n

.meas tran vdout0_19ck530 FIND v(dout0_19) AT=540.05n

.meas tran vdout0_20ck530 FIND v(dout0_20) AT=540.05n

.meas tran vdout0_21ck530 FIND v(dout0_21) AT=540.05n

.meas tran vdout0_22ck530 FIND v(dout0_22) AT=540.05n

.meas tran vdout0_23ck530 FIND v(dout0_23) AT=540.05n

.meas tran vdout0_24ck530 FIND v(dout0_24) AT=540.05n

.meas tran vdout0_25ck530 FIND v(dout0_25) AT=540.05n

.meas tran vdout0_26ck530 FIND v(dout0_26) AT=540.05n

.meas tran vdout0_27ck530 FIND v(dout0_27) AT=540.05n

.meas tran vdout0_28ck530 FIND v(dout0_28) AT=540.05n

.meas tran vdout0_29ck530 FIND v(dout0_29) AT=540.05n

.meas tran vdout0_30ck530 FIND v(dout0_30) AT=540.05n

.meas tran vdout0_31ck530 FIND v(dout0_31) AT=540.05n

.meas tran vdout0_32ck530 FIND v(dout0_32) AT=540.05n

.meas tran vdout0_0ck540 FIND v(dout0_0) AT=550.05n

.meas tran vdout0_1ck540 FIND v(dout0_1) AT=550.05n

.meas tran vdout0_2ck540 FIND v(dout0_2) AT=550.05n

.meas tran vdout0_3ck540 FIND v(dout0_3) AT=550.05n

.meas tran vdout0_4ck540 FIND v(dout0_4) AT=550.05n

.meas tran vdout0_5ck540 FIND v(dout0_5) AT=550.05n

.meas tran vdout0_6ck540 FIND v(dout0_6) AT=550.05n

.meas tran vdout0_7ck540 FIND v(dout0_7) AT=550.05n

.meas tran vdout0_8ck540 FIND v(dout0_8) AT=550.05n

.meas tran vdout0_9ck540 FIND v(dout0_9) AT=550.05n

.meas tran vdout0_10ck540 FIND v(dout0_10) AT=550.05n

.meas tran vdout0_11ck540 FIND v(dout0_11) AT=550.05n

.meas tran vdout0_12ck540 FIND v(dout0_12) AT=550.05n

.meas tran vdout0_13ck540 FIND v(dout0_13) AT=550.05n

.meas tran vdout0_14ck540 FIND v(dout0_14) AT=550.05n

.meas tran vdout0_15ck540 FIND v(dout0_15) AT=550.05n

.meas tran vdout0_16ck540 FIND v(dout0_16) AT=550.05n

.meas tran vdout0_17ck540 FIND v(dout0_17) AT=550.05n

.meas tran vdout0_18ck540 FIND v(dout0_18) AT=550.05n

.meas tran vdout0_19ck540 FIND v(dout0_19) AT=550.05n

.meas tran vdout0_20ck540 FIND v(dout0_20) AT=550.05n

.meas tran vdout0_21ck540 FIND v(dout0_21) AT=550.05n

.meas tran vdout0_22ck540 FIND v(dout0_22) AT=550.05n

.meas tran vdout0_23ck540 FIND v(dout0_23) AT=550.05n

.meas tran vdout0_24ck540 FIND v(dout0_24) AT=550.05n

.meas tran vdout0_25ck540 FIND v(dout0_25) AT=550.05n

.meas tran vdout0_26ck540 FIND v(dout0_26) AT=550.05n

.meas tran vdout0_27ck540 FIND v(dout0_27) AT=550.05n

.meas tran vdout0_28ck540 FIND v(dout0_28) AT=550.05n

.meas tran vdout0_29ck540 FIND v(dout0_29) AT=550.05n

.meas tran vdout0_30ck540 FIND v(dout0_30) AT=550.05n

.meas tran vdout0_31ck540 FIND v(dout0_31) AT=550.05n

.meas tran vdout0_32ck540 FIND v(dout0_32) AT=550.05n

.meas tran vdout0_0ck560 FIND v(dout0_0) AT=570.05n

.meas tran vdout0_1ck560 FIND v(dout0_1) AT=570.05n

.meas tran vdout0_2ck560 FIND v(dout0_2) AT=570.05n

.meas tran vdout0_3ck560 FIND v(dout0_3) AT=570.05n

.meas tran vdout0_4ck560 FIND v(dout0_4) AT=570.05n

.meas tran vdout0_5ck560 FIND v(dout0_5) AT=570.05n

.meas tran vdout0_6ck560 FIND v(dout0_6) AT=570.05n

.meas tran vdout0_7ck560 FIND v(dout0_7) AT=570.05n

.meas tran vdout0_8ck560 FIND v(dout0_8) AT=570.05n

.meas tran vdout0_9ck560 FIND v(dout0_9) AT=570.05n

.meas tran vdout0_10ck560 FIND v(dout0_10) AT=570.05n

.meas tran vdout0_11ck560 FIND v(dout0_11) AT=570.05n

.meas tran vdout0_12ck560 FIND v(dout0_12) AT=570.05n

.meas tran vdout0_13ck560 FIND v(dout0_13) AT=570.05n

.meas tran vdout0_14ck560 FIND v(dout0_14) AT=570.05n

.meas tran vdout0_15ck560 FIND v(dout0_15) AT=570.05n

.meas tran vdout0_16ck560 FIND v(dout0_16) AT=570.05n

.meas tran vdout0_17ck560 FIND v(dout0_17) AT=570.05n

.meas tran vdout0_18ck560 FIND v(dout0_18) AT=570.05n

.meas tran vdout0_19ck560 FIND v(dout0_19) AT=570.05n

.meas tran vdout0_20ck560 FIND v(dout0_20) AT=570.05n

.meas tran vdout0_21ck560 FIND v(dout0_21) AT=570.05n

.meas tran vdout0_22ck560 FIND v(dout0_22) AT=570.05n

.meas tran vdout0_23ck560 FIND v(dout0_23) AT=570.05n

.meas tran vdout0_24ck560 FIND v(dout0_24) AT=570.05n

.meas tran vdout0_25ck560 FIND v(dout0_25) AT=570.05n

.meas tran vdout0_26ck560 FIND v(dout0_26) AT=570.05n

.meas tran vdout0_27ck560 FIND v(dout0_27) AT=570.05n

.meas tran vdout0_28ck560 FIND v(dout0_28) AT=570.05n

.meas tran vdout0_29ck560 FIND v(dout0_29) AT=570.05n

.meas tran vdout0_30ck560 FIND v(dout0_30) AT=570.05n

.meas tran vdout0_31ck560 FIND v(dout0_31) AT=570.05n

.meas tran vdout0_32ck560 FIND v(dout0_32) AT=570.05n

.meas tran vdout0_0ck600 FIND v(dout0_0) AT=610.05n

.meas tran vdout0_1ck600 FIND v(dout0_1) AT=610.05n

.meas tran vdout0_2ck600 FIND v(dout0_2) AT=610.05n

.meas tran vdout0_3ck600 FIND v(dout0_3) AT=610.05n

.meas tran vdout0_4ck600 FIND v(dout0_4) AT=610.05n

.meas tran vdout0_5ck600 FIND v(dout0_5) AT=610.05n

.meas tran vdout0_6ck600 FIND v(dout0_6) AT=610.05n

.meas tran vdout0_7ck600 FIND v(dout0_7) AT=610.05n

.meas tran vdout0_8ck600 FIND v(dout0_8) AT=610.05n

.meas tran vdout0_9ck600 FIND v(dout0_9) AT=610.05n

.meas tran vdout0_10ck600 FIND v(dout0_10) AT=610.05n

.meas tran vdout0_11ck600 FIND v(dout0_11) AT=610.05n

.meas tran vdout0_12ck600 FIND v(dout0_12) AT=610.05n

.meas tran vdout0_13ck600 FIND v(dout0_13) AT=610.05n

.meas tran vdout0_14ck600 FIND v(dout0_14) AT=610.05n

.meas tran vdout0_15ck600 FIND v(dout0_15) AT=610.05n

.meas tran vdout0_16ck600 FIND v(dout0_16) AT=610.05n

.meas tran vdout0_17ck600 FIND v(dout0_17) AT=610.05n

.meas tran vdout0_18ck600 FIND v(dout0_18) AT=610.05n

.meas tran vdout0_19ck600 FIND v(dout0_19) AT=610.05n

.meas tran vdout0_20ck600 FIND v(dout0_20) AT=610.05n

.meas tran vdout0_21ck600 FIND v(dout0_21) AT=610.05n

.meas tran vdout0_22ck600 FIND v(dout0_22) AT=610.05n

.meas tran vdout0_23ck600 FIND v(dout0_23) AT=610.05n

.meas tran vdout0_24ck600 FIND v(dout0_24) AT=610.05n

.meas tran vdout0_25ck600 FIND v(dout0_25) AT=610.05n

.meas tran vdout0_26ck600 FIND v(dout0_26) AT=610.05n

.meas tran vdout0_27ck600 FIND v(dout0_27) AT=610.05n

.meas tran vdout0_28ck600 FIND v(dout0_28) AT=610.05n

.meas tran vdout0_29ck600 FIND v(dout0_29) AT=610.05n

.meas tran vdout0_30ck600 FIND v(dout0_30) AT=610.05n

.meas tran vdout0_31ck600 FIND v(dout0_31) AT=610.05n

.meas tran vdout0_32ck600 FIND v(dout0_32) AT=610.05n

.meas tran vdout0_0ck650 FIND v(dout0_0) AT=660.05n

.meas tran vdout0_1ck650 FIND v(dout0_1) AT=660.05n

.meas tran vdout0_2ck650 FIND v(dout0_2) AT=660.05n

.meas tran vdout0_3ck650 FIND v(dout0_3) AT=660.05n

.meas tran vdout0_4ck650 FIND v(dout0_4) AT=660.05n

.meas tran vdout0_5ck650 FIND v(dout0_5) AT=660.05n

.meas tran vdout0_6ck650 FIND v(dout0_6) AT=660.05n

.meas tran vdout0_7ck650 FIND v(dout0_7) AT=660.05n

.meas tran vdout0_8ck650 FIND v(dout0_8) AT=660.05n

.meas tran vdout0_9ck650 FIND v(dout0_9) AT=660.05n

.meas tran vdout0_10ck650 FIND v(dout0_10) AT=660.05n

.meas tran vdout0_11ck650 FIND v(dout0_11) AT=660.05n

.meas tran vdout0_12ck650 FIND v(dout0_12) AT=660.05n

.meas tran vdout0_13ck650 FIND v(dout0_13) AT=660.05n

.meas tran vdout0_14ck650 FIND v(dout0_14) AT=660.05n

.meas tran vdout0_15ck650 FIND v(dout0_15) AT=660.05n

.meas tran vdout0_16ck650 FIND v(dout0_16) AT=660.05n

.meas tran vdout0_17ck650 FIND v(dout0_17) AT=660.05n

.meas tran vdout0_18ck650 FIND v(dout0_18) AT=660.05n

.meas tran vdout0_19ck650 FIND v(dout0_19) AT=660.05n

.meas tran vdout0_20ck650 FIND v(dout0_20) AT=660.05n

.meas tran vdout0_21ck650 FIND v(dout0_21) AT=660.05n

.meas tran vdout0_22ck650 FIND v(dout0_22) AT=660.05n

.meas tran vdout0_23ck650 FIND v(dout0_23) AT=660.05n

.meas tran vdout0_24ck650 FIND v(dout0_24) AT=660.05n

.meas tran vdout0_25ck650 FIND v(dout0_25) AT=660.05n

.meas tran vdout0_26ck650 FIND v(dout0_26) AT=660.05n

.meas tran vdout0_27ck650 FIND v(dout0_27) AT=660.05n

.meas tran vdout0_28ck650 FIND v(dout0_28) AT=660.05n

.meas tran vdout0_29ck650 FIND v(dout0_29) AT=660.05n

.meas tran vdout0_30ck650 FIND v(dout0_30) AT=660.05n

.meas tran vdout0_31ck650 FIND v(dout0_31) AT=660.05n

.meas tran vdout0_32ck650 FIND v(dout0_32) AT=660.05n

.meas tran vdout0_0ck710 FIND v(dout0_0) AT=720.05n

.meas tran vdout0_1ck710 FIND v(dout0_1) AT=720.05n

.meas tran vdout0_2ck710 FIND v(dout0_2) AT=720.05n

.meas tran vdout0_3ck710 FIND v(dout0_3) AT=720.05n

.meas tran vdout0_4ck710 FIND v(dout0_4) AT=720.05n

.meas tran vdout0_5ck710 FIND v(dout0_5) AT=720.05n

.meas tran vdout0_6ck710 FIND v(dout0_6) AT=720.05n

.meas tran vdout0_7ck710 FIND v(dout0_7) AT=720.05n

.meas tran vdout0_8ck710 FIND v(dout0_8) AT=720.05n

.meas tran vdout0_9ck710 FIND v(dout0_9) AT=720.05n

.meas tran vdout0_10ck710 FIND v(dout0_10) AT=720.05n

.meas tran vdout0_11ck710 FIND v(dout0_11) AT=720.05n

.meas tran vdout0_12ck710 FIND v(dout0_12) AT=720.05n

.meas tran vdout0_13ck710 FIND v(dout0_13) AT=720.05n

.meas tran vdout0_14ck710 FIND v(dout0_14) AT=720.05n

.meas tran vdout0_15ck710 FIND v(dout0_15) AT=720.05n

.meas tran vdout0_16ck710 FIND v(dout0_16) AT=720.05n

.meas tran vdout0_17ck710 FIND v(dout0_17) AT=720.05n

.meas tran vdout0_18ck710 FIND v(dout0_18) AT=720.05n

.meas tran vdout0_19ck710 FIND v(dout0_19) AT=720.05n

.meas tran vdout0_20ck710 FIND v(dout0_20) AT=720.05n

.meas tran vdout0_21ck710 FIND v(dout0_21) AT=720.05n

.meas tran vdout0_22ck710 FIND v(dout0_22) AT=720.05n

.meas tran vdout0_23ck710 FIND v(dout0_23) AT=720.05n

.meas tran vdout0_24ck710 FIND v(dout0_24) AT=720.05n

.meas tran vdout0_25ck710 FIND v(dout0_25) AT=720.05n

.meas tran vdout0_26ck710 FIND v(dout0_26) AT=720.05n

.meas tran vdout0_27ck710 FIND v(dout0_27) AT=720.05n

.meas tran vdout0_28ck710 FIND v(dout0_28) AT=720.05n

.meas tran vdout0_29ck710 FIND v(dout0_29) AT=720.05n

.meas tran vdout0_30ck710 FIND v(dout0_30) AT=720.05n

.meas tran vdout0_31ck710 FIND v(dout0_31) AT=720.05n

.meas tran vdout0_32ck710 FIND v(dout0_32) AT=720.05n

.meas tran vdout0_0ck760 FIND v(dout0_0) AT=770.05n

.meas tran vdout0_1ck760 FIND v(dout0_1) AT=770.05n

.meas tran vdout0_2ck760 FIND v(dout0_2) AT=770.05n

.meas tran vdout0_3ck760 FIND v(dout0_3) AT=770.05n

.meas tran vdout0_4ck760 FIND v(dout0_4) AT=770.05n

.meas tran vdout0_5ck760 FIND v(dout0_5) AT=770.05n

.meas tran vdout0_6ck760 FIND v(dout0_6) AT=770.05n

.meas tran vdout0_7ck760 FIND v(dout0_7) AT=770.05n

.meas tran vdout0_8ck760 FIND v(dout0_8) AT=770.05n

.meas tran vdout0_9ck760 FIND v(dout0_9) AT=770.05n

.meas tran vdout0_10ck760 FIND v(dout0_10) AT=770.05n

.meas tran vdout0_11ck760 FIND v(dout0_11) AT=770.05n

.meas tran vdout0_12ck760 FIND v(dout0_12) AT=770.05n

.meas tran vdout0_13ck760 FIND v(dout0_13) AT=770.05n

.meas tran vdout0_14ck760 FIND v(dout0_14) AT=770.05n

.meas tran vdout0_15ck760 FIND v(dout0_15) AT=770.05n

.meas tran vdout0_16ck760 FIND v(dout0_16) AT=770.05n

.meas tran vdout0_17ck760 FIND v(dout0_17) AT=770.05n

.meas tran vdout0_18ck760 FIND v(dout0_18) AT=770.05n

.meas tran vdout0_19ck760 FIND v(dout0_19) AT=770.05n

.meas tran vdout0_20ck760 FIND v(dout0_20) AT=770.05n

.meas tran vdout0_21ck760 FIND v(dout0_21) AT=770.05n

.meas tran vdout0_22ck760 FIND v(dout0_22) AT=770.05n

.meas tran vdout0_23ck760 FIND v(dout0_23) AT=770.05n

.meas tran vdout0_24ck760 FIND v(dout0_24) AT=770.05n

.meas tran vdout0_25ck760 FIND v(dout0_25) AT=770.05n

.meas tran vdout0_26ck760 FIND v(dout0_26) AT=770.05n

.meas tran vdout0_27ck760 FIND v(dout0_27) AT=770.05n

.meas tran vdout0_28ck760 FIND v(dout0_28) AT=770.05n

.meas tran vdout0_29ck760 FIND v(dout0_29) AT=770.05n

.meas tran vdout0_30ck760 FIND v(dout0_30) AT=770.05n

.meas tran vdout0_31ck760 FIND v(dout0_31) AT=770.05n

.meas tran vdout0_32ck760 FIND v(dout0_32) AT=770.05n

.meas tran vdout0_0ck770 FIND v(dout0_0) AT=780.05n

.meas tran vdout0_1ck770 FIND v(dout0_1) AT=780.05n

.meas tran vdout0_2ck770 FIND v(dout0_2) AT=780.05n

.meas tran vdout0_3ck770 FIND v(dout0_3) AT=780.05n

.meas tran vdout0_4ck770 FIND v(dout0_4) AT=780.05n

.meas tran vdout0_5ck770 FIND v(dout0_5) AT=780.05n

.meas tran vdout0_6ck770 FIND v(dout0_6) AT=780.05n

.meas tran vdout0_7ck770 FIND v(dout0_7) AT=780.05n

.meas tran vdout0_8ck770 FIND v(dout0_8) AT=780.05n

.meas tran vdout0_9ck770 FIND v(dout0_9) AT=780.05n

.meas tran vdout0_10ck770 FIND v(dout0_10) AT=780.05n

.meas tran vdout0_11ck770 FIND v(dout0_11) AT=780.05n

.meas tran vdout0_12ck770 FIND v(dout0_12) AT=780.05n

.meas tran vdout0_13ck770 FIND v(dout0_13) AT=780.05n

.meas tran vdout0_14ck770 FIND v(dout0_14) AT=780.05n

.meas tran vdout0_15ck770 FIND v(dout0_15) AT=780.05n

.meas tran vdout0_16ck770 FIND v(dout0_16) AT=780.05n

.meas tran vdout0_17ck770 FIND v(dout0_17) AT=780.05n

.meas tran vdout0_18ck770 FIND v(dout0_18) AT=780.05n

.meas tran vdout0_19ck770 FIND v(dout0_19) AT=780.05n

.meas tran vdout0_20ck770 FIND v(dout0_20) AT=780.05n

.meas tran vdout0_21ck770 FIND v(dout0_21) AT=780.05n

.meas tran vdout0_22ck770 FIND v(dout0_22) AT=780.05n

.meas tran vdout0_23ck770 FIND v(dout0_23) AT=780.05n

.meas tran vdout0_24ck770 FIND v(dout0_24) AT=780.05n

.meas tran vdout0_25ck770 FIND v(dout0_25) AT=780.05n

.meas tran vdout0_26ck770 FIND v(dout0_26) AT=780.05n

.meas tran vdout0_27ck770 FIND v(dout0_27) AT=780.05n

.meas tran vdout0_28ck770 FIND v(dout0_28) AT=780.05n

.meas tran vdout0_29ck770 FIND v(dout0_29) AT=780.05n

.meas tran vdout0_30ck770 FIND v(dout0_30) AT=780.05n

.meas tran vdout0_31ck770 FIND v(dout0_31) AT=780.05n

.meas tran vdout0_32ck770 FIND v(dout0_32) AT=780.05n

.meas tran vdout0_0ck790 FIND v(dout0_0) AT=800.05n

.meas tran vdout0_1ck790 FIND v(dout0_1) AT=800.05n

.meas tran vdout0_2ck790 FIND v(dout0_2) AT=800.05n

.meas tran vdout0_3ck790 FIND v(dout0_3) AT=800.05n

.meas tran vdout0_4ck790 FIND v(dout0_4) AT=800.05n

.meas tran vdout0_5ck790 FIND v(dout0_5) AT=800.05n

.meas tran vdout0_6ck790 FIND v(dout0_6) AT=800.05n

.meas tran vdout0_7ck790 FIND v(dout0_7) AT=800.05n

.meas tran vdout0_8ck790 FIND v(dout0_8) AT=800.05n

.meas tran vdout0_9ck790 FIND v(dout0_9) AT=800.05n

.meas tran vdout0_10ck790 FIND v(dout0_10) AT=800.05n

.meas tran vdout0_11ck790 FIND v(dout0_11) AT=800.05n

.meas tran vdout0_12ck790 FIND v(dout0_12) AT=800.05n

.meas tran vdout0_13ck790 FIND v(dout0_13) AT=800.05n

.meas tran vdout0_14ck790 FIND v(dout0_14) AT=800.05n

.meas tran vdout0_15ck790 FIND v(dout0_15) AT=800.05n

.meas tran vdout0_16ck790 FIND v(dout0_16) AT=800.05n

.meas tran vdout0_17ck790 FIND v(dout0_17) AT=800.05n

.meas tran vdout0_18ck790 FIND v(dout0_18) AT=800.05n

.meas tran vdout0_19ck790 FIND v(dout0_19) AT=800.05n

.meas tran vdout0_20ck790 FIND v(dout0_20) AT=800.05n

.meas tran vdout0_21ck790 FIND v(dout0_21) AT=800.05n

.meas tran vdout0_22ck790 FIND v(dout0_22) AT=800.05n

.meas tran vdout0_23ck790 FIND v(dout0_23) AT=800.05n

.meas tran vdout0_24ck790 FIND v(dout0_24) AT=800.05n

.meas tran vdout0_25ck790 FIND v(dout0_25) AT=800.05n

.meas tran vdout0_26ck790 FIND v(dout0_26) AT=800.05n

.meas tran vdout0_27ck790 FIND v(dout0_27) AT=800.05n

.meas tran vdout0_28ck790 FIND v(dout0_28) AT=800.05n

.meas tran vdout0_29ck790 FIND v(dout0_29) AT=800.05n

.meas tran vdout0_30ck790 FIND v(dout0_30) AT=800.05n

.meas tran vdout0_31ck790 FIND v(dout0_31) AT=800.05n

.meas tran vdout0_32ck790 FIND v(dout0_32) AT=800.05n

.meas tran vdout0_0ck800 FIND v(dout0_0) AT=810.05n

.meas tran vdout0_1ck800 FIND v(dout0_1) AT=810.05n

.meas tran vdout0_2ck800 FIND v(dout0_2) AT=810.05n

.meas tran vdout0_3ck800 FIND v(dout0_3) AT=810.05n

.meas tran vdout0_4ck800 FIND v(dout0_4) AT=810.05n

.meas tran vdout0_5ck800 FIND v(dout0_5) AT=810.05n

.meas tran vdout0_6ck800 FIND v(dout0_6) AT=810.05n

.meas tran vdout0_7ck800 FIND v(dout0_7) AT=810.05n

.meas tran vdout0_8ck800 FIND v(dout0_8) AT=810.05n

.meas tran vdout0_9ck800 FIND v(dout0_9) AT=810.05n

.meas tran vdout0_10ck800 FIND v(dout0_10) AT=810.05n

.meas tran vdout0_11ck800 FIND v(dout0_11) AT=810.05n

.meas tran vdout0_12ck800 FIND v(dout0_12) AT=810.05n

.meas tran vdout0_13ck800 FIND v(dout0_13) AT=810.05n

.meas tran vdout0_14ck800 FIND v(dout0_14) AT=810.05n

.meas tran vdout0_15ck800 FIND v(dout0_15) AT=810.05n

.meas tran vdout0_16ck800 FIND v(dout0_16) AT=810.05n

.meas tran vdout0_17ck800 FIND v(dout0_17) AT=810.05n

.meas tran vdout0_18ck800 FIND v(dout0_18) AT=810.05n

.meas tran vdout0_19ck800 FIND v(dout0_19) AT=810.05n

.meas tran vdout0_20ck800 FIND v(dout0_20) AT=810.05n

.meas tran vdout0_21ck800 FIND v(dout0_21) AT=810.05n

.meas tran vdout0_22ck800 FIND v(dout0_22) AT=810.05n

.meas tran vdout0_23ck800 FIND v(dout0_23) AT=810.05n

.meas tran vdout0_24ck800 FIND v(dout0_24) AT=810.05n

.meas tran vdout0_25ck800 FIND v(dout0_25) AT=810.05n

.meas tran vdout0_26ck800 FIND v(dout0_26) AT=810.05n

.meas tran vdout0_27ck800 FIND v(dout0_27) AT=810.05n

.meas tran vdout0_28ck800 FIND v(dout0_28) AT=810.05n

.meas tran vdout0_29ck800 FIND v(dout0_29) AT=810.05n

.meas tran vdout0_30ck800 FIND v(dout0_30) AT=810.05n

.meas tran vdout0_31ck800 FIND v(dout0_31) AT=810.05n

.meas tran vdout0_32ck800 FIND v(dout0_32) AT=810.05n

.meas tran vdout0_0ck810 FIND v(dout0_0) AT=820.05n

.meas tran vdout0_1ck810 FIND v(dout0_1) AT=820.05n

.meas tran vdout0_2ck810 FIND v(dout0_2) AT=820.05n

.meas tran vdout0_3ck810 FIND v(dout0_3) AT=820.05n

.meas tran vdout0_4ck810 FIND v(dout0_4) AT=820.05n

.meas tran vdout0_5ck810 FIND v(dout0_5) AT=820.05n

.meas tran vdout0_6ck810 FIND v(dout0_6) AT=820.05n

.meas tran vdout0_7ck810 FIND v(dout0_7) AT=820.05n

.meas tran vdout0_8ck810 FIND v(dout0_8) AT=820.05n

.meas tran vdout0_9ck810 FIND v(dout0_9) AT=820.05n

.meas tran vdout0_10ck810 FIND v(dout0_10) AT=820.05n

.meas tran vdout0_11ck810 FIND v(dout0_11) AT=820.05n

.meas tran vdout0_12ck810 FIND v(dout0_12) AT=820.05n

.meas tran vdout0_13ck810 FIND v(dout0_13) AT=820.05n

.meas tran vdout0_14ck810 FIND v(dout0_14) AT=820.05n

.meas tran vdout0_15ck810 FIND v(dout0_15) AT=820.05n

.meas tran vdout0_16ck810 FIND v(dout0_16) AT=820.05n

.meas tran vdout0_17ck810 FIND v(dout0_17) AT=820.05n

.meas tran vdout0_18ck810 FIND v(dout0_18) AT=820.05n

.meas tran vdout0_19ck810 FIND v(dout0_19) AT=820.05n

.meas tran vdout0_20ck810 FIND v(dout0_20) AT=820.05n

.meas tran vdout0_21ck810 FIND v(dout0_21) AT=820.05n

.meas tran vdout0_22ck810 FIND v(dout0_22) AT=820.05n

.meas tran vdout0_23ck810 FIND v(dout0_23) AT=820.05n

.meas tran vdout0_24ck810 FIND v(dout0_24) AT=820.05n

.meas tran vdout0_25ck810 FIND v(dout0_25) AT=820.05n

.meas tran vdout0_26ck810 FIND v(dout0_26) AT=820.05n

.meas tran vdout0_27ck810 FIND v(dout0_27) AT=820.05n

.meas tran vdout0_28ck810 FIND v(dout0_28) AT=820.05n

.meas tran vdout0_29ck810 FIND v(dout0_29) AT=820.05n

.meas tran vdout0_30ck810 FIND v(dout0_30) AT=820.05n

.meas tran vdout0_31ck810 FIND v(dout0_31) AT=820.05n

.meas tran vdout0_32ck810 FIND v(dout0_32) AT=820.05n

.meas tran vdout0_0ck820 FIND v(dout0_0) AT=830.05n

.meas tran vdout0_1ck820 FIND v(dout0_1) AT=830.05n

.meas tran vdout0_2ck820 FIND v(dout0_2) AT=830.05n

.meas tran vdout0_3ck820 FIND v(dout0_3) AT=830.05n

.meas tran vdout0_4ck820 FIND v(dout0_4) AT=830.05n

.meas tran vdout0_5ck820 FIND v(dout0_5) AT=830.05n

.meas tran vdout0_6ck820 FIND v(dout0_6) AT=830.05n

.meas tran vdout0_7ck820 FIND v(dout0_7) AT=830.05n

.meas tran vdout0_8ck820 FIND v(dout0_8) AT=830.05n

.meas tran vdout0_9ck820 FIND v(dout0_9) AT=830.05n

.meas tran vdout0_10ck820 FIND v(dout0_10) AT=830.05n

.meas tran vdout0_11ck820 FIND v(dout0_11) AT=830.05n

.meas tran vdout0_12ck820 FIND v(dout0_12) AT=830.05n

.meas tran vdout0_13ck820 FIND v(dout0_13) AT=830.05n

.meas tran vdout0_14ck820 FIND v(dout0_14) AT=830.05n

.meas tran vdout0_15ck820 FIND v(dout0_15) AT=830.05n

.meas tran vdout0_16ck820 FIND v(dout0_16) AT=830.05n

.meas tran vdout0_17ck820 FIND v(dout0_17) AT=830.05n

.meas tran vdout0_18ck820 FIND v(dout0_18) AT=830.05n

.meas tran vdout0_19ck820 FIND v(dout0_19) AT=830.05n

.meas tran vdout0_20ck820 FIND v(dout0_20) AT=830.05n

.meas tran vdout0_21ck820 FIND v(dout0_21) AT=830.05n

.meas tran vdout0_22ck820 FIND v(dout0_22) AT=830.05n

.meas tran vdout0_23ck820 FIND v(dout0_23) AT=830.05n

.meas tran vdout0_24ck820 FIND v(dout0_24) AT=830.05n

.meas tran vdout0_25ck820 FIND v(dout0_25) AT=830.05n

.meas tran vdout0_26ck820 FIND v(dout0_26) AT=830.05n

.meas tran vdout0_27ck820 FIND v(dout0_27) AT=830.05n

.meas tran vdout0_28ck820 FIND v(dout0_28) AT=830.05n

.meas tran vdout0_29ck820 FIND v(dout0_29) AT=830.05n

.meas tran vdout0_30ck820 FIND v(dout0_30) AT=830.05n

.meas tran vdout0_31ck820 FIND v(dout0_31) AT=830.05n

.meas tran vdout0_32ck820 FIND v(dout0_32) AT=830.05n

.meas tran vdout0_0ck870 FIND v(dout0_0) AT=880.05n

.meas tran vdout0_1ck870 FIND v(dout0_1) AT=880.05n

.meas tran vdout0_2ck870 FIND v(dout0_2) AT=880.05n

.meas tran vdout0_3ck870 FIND v(dout0_3) AT=880.05n

.meas tran vdout0_4ck870 FIND v(dout0_4) AT=880.05n

.meas tran vdout0_5ck870 FIND v(dout0_5) AT=880.05n

.meas tran vdout0_6ck870 FIND v(dout0_6) AT=880.05n

.meas tran vdout0_7ck870 FIND v(dout0_7) AT=880.05n

.meas tran vdout0_8ck870 FIND v(dout0_8) AT=880.05n

.meas tran vdout0_9ck870 FIND v(dout0_9) AT=880.05n

.meas tran vdout0_10ck870 FIND v(dout0_10) AT=880.05n

.meas tran vdout0_11ck870 FIND v(dout0_11) AT=880.05n

.meas tran vdout0_12ck870 FIND v(dout0_12) AT=880.05n

.meas tran vdout0_13ck870 FIND v(dout0_13) AT=880.05n

.meas tran vdout0_14ck870 FIND v(dout0_14) AT=880.05n

.meas tran vdout0_15ck870 FIND v(dout0_15) AT=880.05n

.meas tran vdout0_16ck870 FIND v(dout0_16) AT=880.05n

.meas tran vdout0_17ck870 FIND v(dout0_17) AT=880.05n

.meas tran vdout0_18ck870 FIND v(dout0_18) AT=880.05n

.meas tran vdout0_19ck870 FIND v(dout0_19) AT=880.05n

.meas tran vdout0_20ck870 FIND v(dout0_20) AT=880.05n

.meas tran vdout0_21ck870 FIND v(dout0_21) AT=880.05n

.meas tran vdout0_22ck870 FIND v(dout0_22) AT=880.05n

.meas tran vdout0_23ck870 FIND v(dout0_23) AT=880.05n

.meas tran vdout0_24ck870 FIND v(dout0_24) AT=880.05n

.meas tran vdout0_25ck870 FIND v(dout0_25) AT=880.05n

.meas tran vdout0_26ck870 FIND v(dout0_26) AT=880.05n

.meas tran vdout0_27ck870 FIND v(dout0_27) AT=880.05n

.meas tran vdout0_28ck870 FIND v(dout0_28) AT=880.05n

.meas tran vdout0_29ck870 FIND v(dout0_29) AT=880.05n

.meas tran vdout0_30ck870 FIND v(dout0_30) AT=880.05n

.meas tran vdout0_31ck870 FIND v(dout0_31) AT=880.05n

.meas tran vdout0_32ck870 FIND v(dout0_32) AT=880.05n

.meas tran vdout0_0ck910 FIND v(dout0_0) AT=920.05n

.meas tran vdout0_1ck910 FIND v(dout0_1) AT=920.05n

.meas tran vdout0_2ck910 FIND v(dout0_2) AT=920.05n

.meas tran vdout0_3ck910 FIND v(dout0_3) AT=920.05n

.meas tran vdout0_4ck910 FIND v(dout0_4) AT=920.05n

.meas tran vdout0_5ck910 FIND v(dout0_5) AT=920.05n

.meas tran vdout0_6ck910 FIND v(dout0_6) AT=920.05n

.meas tran vdout0_7ck910 FIND v(dout0_7) AT=920.05n

.meas tran vdout0_8ck910 FIND v(dout0_8) AT=920.05n

.meas tran vdout0_9ck910 FIND v(dout0_9) AT=920.05n

.meas tran vdout0_10ck910 FIND v(dout0_10) AT=920.05n

.meas tran vdout0_11ck910 FIND v(dout0_11) AT=920.05n

.meas tran vdout0_12ck910 FIND v(dout0_12) AT=920.05n

.meas tran vdout0_13ck910 FIND v(dout0_13) AT=920.05n

.meas tran vdout0_14ck910 FIND v(dout0_14) AT=920.05n

.meas tran vdout0_15ck910 FIND v(dout0_15) AT=920.05n

.meas tran vdout0_16ck910 FIND v(dout0_16) AT=920.05n

.meas tran vdout0_17ck910 FIND v(dout0_17) AT=920.05n

.meas tran vdout0_18ck910 FIND v(dout0_18) AT=920.05n

.meas tran vdout0_19ck910 FIND v(dout0_19) AT=920.05n

.meas tran vdout0_20ck910 FIND v(dout0_20) AT=920.05n

.meas tran vdout0_21ck910 FIND v(dout0_21) AT=920.05n

.meas tran vdout0_22ck910 FIND v(dout0_22) AT=920.05n

.meas tran vdout0_23ck910 FIND v(dout0_23) AT=920.05n

.meas tran vdout0_24ck910 FIND v(dout0_24) AT=920.05n

.meas tran vdout0_25ck910 FIND v(dout0_25) AT=920.05n

.meas tran vdout0_26ck910 FIND v(dout0_26) AT=920.05n

.meas tran vdout0_27ck910 FIND v(dout0_27) AT=920.05n

.meas tran vdout0_28ck910 FIND v(dout0_28) AT=920.05n

.meas tran vdout0_29ck910 FIND v(dout0_29) AT=920.05n

.meas tran vdout0_30ck910 FIND v(dout0_30) AT=920.05n

.meas tran vdout0_31ck910 FIND v(dout0_31) AT=920.05n

.meas tran vdout0_32ck910 FIND v(dout0_32) AT=920.05n

.meas tran vdout0_0ck920 FIND v(dout0_0) AT=930.05n

.meas tran vdout0_1ck920 FIND v(dout0_1) AT=930.05n

.meas tran vdout0_2ck920 FIND v(dout0_2) AT=930.05n

.meas tran vdout0_3ck920 FIND v(dout0_3) AT=930.05n

.meas tran vdout0_4ck920 FIND v(dout0_4) AT=930.05n

.meas tran vdout0_5ck920 FIND v(dout0_5) AT=930.05n

.meas tran vdout0_6ck920 FIND v(dout0_6) AT=930.05n

.meas tran vdout0_7ck920 FIND v(dout0_7) AT=930.05n

.meas tran vdout0_8ck920 FIND v(dout0_8) AT=930.05n

.meas tran vdout0_9ck920 FIND v(dout0_9) AT=930.05n

.meas tran vdout0_10ck920 FIND v(dout0_10) AT=930.05n

.meas tran vdout0_11ck920 FIND v(dout0_11) AT=930.05n

.meas tran vdout0_12ck920 FIND v(dout0_12) AT=930.05n

.meas tran vdout0_13ck920 FIND v(dout0_13) AT=930.05n

.meas tran vdout0_14ck920 FIND v(dout0_14) AT=930.05n

.meas tran vdout0_15ck920 FIND v(dout0_15) AT=930.05n

.meas tran vdout0_16ck920 FIND v(dout0_16) AT=930.05n

.meas tran vdout0_17ck920 FIND v(dout0_17) AT=930.05n

.meas tran vdout0_18ck920 FIND v(dout0_18) AT=930.05n

.meas tran vdout0_19ck920 FIND v(dout0_19) AT=930.05n

.meas tran vdout0_20ck920 FIND v(dout0_20) AT=930.05n

.meas tran vdout0_21ck920 FIND v(dout0_21) AT=930.05n

.meas tran vdout0_22ck920 FIND v(dout0_22) AT=930.05n

.meas tran vdout0_23ck920 FIND v(dout0_23) AT=930.05n

.meas tran vdout0_24ck920 FIND v(dout0_24) AT=930.05n

.meas tran vdout0_25ck920 FIND v(dout0_25) AT=930.05n

.meas tran vdout0_26ck920 FIND v(dout0_26) AT=930.05n

.meas tran vdout0_27ck920 FIND v(dout0_27) AT=930.05n

.meas tran vdout0_28ck920 FIND v(dout0_28) AT=930.05n

.meas tran vdout0_29ck920 FIND v(dout0_29) AT=930.05n

.meas tran vdout0_30ck920 FIND v(dout0_30) AT=930.05n

.meas tran vdout0_31ck920 FIND v(dout0_31) AT=930.05n

.meas tran vdout0_32ck920 FIND v(dout0_32) AT=930.05n

.meas tran vdout0_0ck940 FIND v(dout0_0) AT=950.05n

.meas tran vdout0_1ck940 FIND v(dout0_1) AT=950.05n

.meas tran vdout0_2ck940 FIND v(dout0_2) AT=950.05n

.meas tran vdout0_3ck940 FIND v(dout0_3) AT=950.05n

.meas tran vdout0_4ck940 FIND v(dout0_4) AT=950.05n

.meas tran vdout0_5ck940 FIND v(dout0_5) AT=950.05n

.meas tran vdout0_6ck940 FIND v(dout0_6) AT=950.05n

.meas tran vdout0_7ck940 FIND v(dout0_7) AT=950.05n

.meas tran vdout0_8ck940 FIND v(dout0_8) AT=950.05n

.meas tran vdout0_9ck940 FIND v(dout0_9) AT=950.05n

.meas tran vdout0_10ck940 FIND v(dout0_10) AT=950.05n

.meas tran vdout0_11ck940 FIND v(dout0_11) AT=950.05n

.meas tran vdout0_12ck940 FIND v(dout0_12) AT=950.05n

.meas tran vdout0_13ck940 FIND v(dout0_13) AT=950.05n

.meas tran vdout0_14ck940 FIND v(dout0_14) AT=950.05n

.meas tran vdout0_15ck940 FIND v(dout0_15) AT=950.05n

.meas tran vdout0_16ck940 FIND v(dout0_16) AT=950.05n

.meas tran vdout0_17ck940 FIND v(dout0_17) AT=950.05n

.meas tran vdout0_18ck940 FIND v(dout0_18) AT=950.05n

.meas tran vdout0_19ck940 FIND v(dout0_19) AT=950.05n

.meas tran vdout0_20ck940 FIND v(dout0_20) AT=950.05n

.meas tran vdout0_21ck940 FIND v(dout0_21) AT=950.05n

.meas tran vdout0_22ck940 FIND v(dout0_22) AT=950.05n

.meas tran vdout0_23ck940 FIND v(dout0_23) AT=950.05n

.meas tran vdout0_24ck940 FIND v(dout0_24) AT=950.05n

.meas tran vdout0_25ck940 FIND v(dout0_25) AT=950.05n

.meas tran vdout0_26ck940 FIND v(dout0_26) AT=950.05n

.meas tran vdout0_27ck940 FIND v(dout0_27) AT=950.05n

.meas tran vdout0_28ck940 FIND v(dout0_28) AT=950.05n

.meas tran vdout0_29ck940 FIND v(dout0_29) AT=950.05n

.meas tran vdout0_30ck940 FIND v(dout0_30) AT=950.05n

.meas tran vdout0_31ck940 FIND v(dout0_31) AT=950.05n

.meas tran vdout0_32ck940 FIND v(dout0_32) AT=950.05n

.meas tran vdout0_0ck950 FIND v(dout0_0) AT=960.05n

.meas tran vdout0_1ck950 FIND v(dout0_1) AT=960.05n

.meas tran vdout0_2ck950 FIND v(dout0_2) AT=960.05n

.meas tran vdout0_3ck950 FIND v(dout0_3) AT=960.05n

.meas tran vdout0_4ck950 FIND v(dout0_4) AT=960.05n

.meas tran vdout0_5ck950 FIND v(dout0_5) AT=960.05n

.meas tran vdout0_6ck950 FIND v(dout0_6) AT=960.05n

.meas tran vdout0_7ck950 FIND v(dout0_7) AT=960.05n

.meas tran vdout0_8ck950 FIND v(dout0_8) AT=960.05n

.meas tran vdout0_9ck950 FIND v(dout0_9) AT=960.05n

.meas tran vdout0_10ck950 FIND v(dout0_10) AT=960.05n

.meas tran vdout0_11ck950 FIND v(dout0_11) AT=960.05n

.meas tran vdout0_12ck950 FIND v(dout0_12) AT=960.05n

.meas tran vdout0_13ck950 FIND v(dout0_13) AT=960.05n

.meas tran vdout0_14ck950 FIND v(dout0_14) AT=960.05n

.meas tran vdout0_15ck950 FIND v(dout0_15) AT=960.05n

.meas tran vdout0_16ck950 FIND v(dout0_16) AT=960.05n

.meas tran vdout0_17ck950 FIND v(dout0_17) AT=960.05n

.meas tran vdout0_18ck950 FIND v(dout0_18) AT=960.05n

.meas tran vdout0_19ck950 FIND v(dout0_19) AT=960.05n

.meas tran vdout0_20ck950 FIND v(dout0_20) AT=960.05n

.meas tran vdout0_21ck950 FIND v(dout0_21) AT=960.05n

.meas tran vdout0_22ck950 FIND v(dout0_22) AT=960.05n

.meas tran vdout0_23ck950 FIND v(dout0_23) AT=960.05n

.meas tran vdout0_24ck950 FIND v(dout0_24) AT=960.05n

.meas tran vdout0_25ck950 FIND v(dout0_25) AT=960.05n

.meas tran vdout0_26ck950 FIND v(dout0_26) AT=960.05n

.meas tran vdout0_27ck950 FIND v(dout0_27) AT=960.05n

.meas tran vdout0_28ck950 FIND v(dout0_28) AT=960.05n

.meas tran vdout0_29ck950 FIND v(dout0_29) AT=960.05n

.meas tran vdout0_30ck950 FIND v(dout0_30) AT=960.05n

.meas tran vdout0_31ck950 FIND v(dout0_31) AT=960.05n

.meas tran vdout0_32ck950 FIND v(dout0_32) AT=960.05n

.meas tran vdout0_0ck970 FIND v(dout0_0) AT=980.05n

.meas tran vdout0_1ck970 FIND v(dout0_1) AT=980.05n

.meas tran vdout0_2ck970 FIND v(dout0_2) AT=980.05n

.meas tran vdout0_3ck970 FIND v(dout0_3) AT=980.05n

.meas tran vdout0_4ck970 FIND v(dout0_4) AT=980.05n

.meas tran vdout0_5ck970 FIND v(dout0_5) AT=980.05n

.meas tran vdout0_6ck970 FIND v(dout0_6) AT=980.05n

.meas tran vdout0_7ck970 FIND v(dout0_7) AT=980.05n

.meas tran vdout0_8ck970 FIND v(dout0_8) AT=980.05n

.meas tran vdout0_9ck970 FIND v(dout0_9) AT=980.05n

.meas tran vdout0_10ck970 FIND v(dout0_10) AT=980.05n

.meas tran vdout0_11ck970 FIND v(dout0_11) AT=980.05n

.meas tran vdout0_12ck970 FIND v(dout0_12) AT=980.05n

.meas tran vdout0_13ck970 FIND v(dout0_13) AT=980.05n

.meas tran vdout0_14ck970 FIND v(dout0_14) AT=980.05n

.meas tran vdout0_15ck970 FIND v(dout0_15) AT=980.05n

.meas tran vdout0_16ck970 FIND v(dout0_16) AT=980.05n

.meas tran vdout0_17ck970 FIND v(dout0_17) AT=980.05n

.meas tran vdout0_18ck970 FIND v(dout0_18) AT=980.05n

.meas tran vdout0_19ck970 FIND v(dout0_19) AT=980.05n

.meas tran vdout0_20ck970 FIND v(dout0_20) AT=980.05n

.meas tran vdout0_21ck970 FIND v(dout0_21) AT=980.05n

.meas tran vdout0_22ck970 FIND v(dout0_22) AT=980.05n

.meas tran vdout0_23ck970 FIND v(dout0_23) AT=980.05n

.meas tran vdout0_24ck970 FIND v(dout0_24) AT=980.05n

.meas tran vdout0_25ck970 FIND v(dout0_25) AT=980.05n

.meas tran vdout0_26ck970 FIND v(dout0_26) AT=980.05n

.meas tran vdout0_27ck970 FIND v(dout0_27) AT=980.05n

.meas tran vdout0_28ck970 FIND v(dout0_28) AT=980.05n

.meas tran vdout0_29ck970 FIND v(dout0_29) AT=980.05n

.meas tran vdout0_30ck970 FIND v(dout0_30) AT=980.05n

.meas tran vdout0_31ck970 FIND v(dout0_31) AT=980.05n

.meas tran vdout0_32ck970 FIND v(dout0_32) AT=980.05n

.meas tran vdout0_0ck980 FIND v(dout0_0) AT=990.05n

.meas tran vdout0_1ck980 FIND v(dout0_1) AT=990.05n

.meas tran vdout0_2ck980 FIND v(dout0_2) AT=990.05n

.meas tran vdout0_3ck980 FIND v(dout0_3) AT=990.05n

.meas tran vdout0_4ck980 FIND v(dout0_4) AT=990.05n

.meas tran vdout0_5ck980 FIND v(dout0_5) AT=990.05n

.meas tran vdout0_6ck980 FIND v(dout0_6) AT=990.05n

.meas tran vdout0_7ck980 FIND v(dout0_7) AT=990.05n

.meas tran vdout0_8ck980 FIND v(dout0_8) AT=990.05n

.meas tran vdout0_9ck980 FIND v(dout0_9) AT=990.05n

.meas tran vdout0_10ck980 FIND v(dout0_10) AT=990.05n

.meas tran vdout0_11ck980 FIND v(dout0_11) AT=990.05n

.meas tran vdout0_12ck980 FIND v(dout0_12) AT=990.05n

.meas tran vdout0_13ck980 FIND v(dout0_13) AT=990.05n

.meas tran vdout0_14ck980 FIND v(dout0_14) AT=990.05n

.meas tran vdout0_15ck980 FIND v(dout0_15) AT=990.05n

.meas tran vdout0_16ck980 FIND v(dout0_16) AT=990.05n

.meas tran vdout0_17ck980 FIND v(dout0_17) AT=990.05n

.meas tran vdout0_18ck980 FIND v(dout0_18) AT=990.05n

.meas tran vdout0_19ck980 FIND v(dout0_19) AT=990.05n

.meas tran vdout0_20ck980 FIND v(dout0_20) AT=990.05n

.meas tran vdout0_21ck980 FIND v(dout0_21) AT=990.05n

.meas tran vdout0_22ck980 FIND v(dout0_22) AT=990.05n

.meas tran vdout0_23ck980 FIND v(dout0_23) AT=990.05n

.meas tran vdout0_24ck980 FIND v(dout0_24) AT=990.05n

.meas tran vdout0_25ck980 FIND v(dout0_25) AT=990.05n

.meas tran vdout0_26ck980 FIND v(dout0_26) AT=990.05n

.meas tran vdout0_27ck980 FIND v(dout0_27) AT=990.05n

.meas tran vdout0_28ck980 FIND v(dout0_28) AT=990.05n

.meas tran vdout0_29ck980 FIND v(dout0_29) AT=990.05n

.meas tran vdout0_30ck980 FIND v(dout0_30) AT=990.05n

.meas tran vdout0_31ck980 FIND v(dout0_31) AT=990.05n

.meas tran vdout0_32ck980 FIND v(dout0_32) AT=990.05n

.meas tran vdout0_0ck990 FIND v(dout0_0) AT=1000.05n

.meas tran vdout0_1ck990 FIND v(dout0_1) AT=1000.05n

.meas tran vdout0_2ck990 FIND v(dout0_2) AT=1000.05n

.meas tran vdout0_3ck990 FIND v(dout0_3) AT=1000.05n

.meas tran vdout0_4ck990 FIND v(dout0_4) AT=1000.05n

.meas tran vdout0_5ck990 FIND v(dout0_5) AT=1000.05n

.meas tran vdout0_6ck990 FIND v(dout0_6) AT=1000.05n

.meas tran vdout0_7ck990 FIND v(dout0_7) AT=1000.05n

.meas tran vdout0_8ck990 FIND v(dout0_8) AT=1000.05n

.meas tran vdout0_9ck990 FIND v(dout0_9) AT=1000.05n

.meas tran vdout0_10ck990 FIND v(dout0_10) AT=1000.05n

.meas tran vdout0_11ck990 FIND v(dout0_11) AT=1000.05n

.meas tran vdout0_12ck990 FIND v(dout0_12) AT=1000.05n

.meas tran vdout0_13ck990 FIND v(dout0_13) AT=1000.05n

.meas tran vdout0_14ck990 FIND v(dout0_14) AT=1000.05n

.meas tran vdout0_15ck990 FIND v(dout0_15) AT=1000.05n

.meas tran vdout0_16ck990 FIND v(dout0_16) AT=1000.05n

.meas tran vdout0_17ck990 FIND v(dout0_17) AT=1000.05n

.meas tran vdout0_18ck990 FIND v(dout0_18) AT=1000.05n

.meas tran vdout0_19ck990 FIND v(dout0_19) AT=1000.05n

.meas tran vdout0_20ck990 FIND v(dout0_20) AT=1000.05n

.meas tran vdout0_21ck990 FIND v(dout0_21) AT=1000.05n

.meas tran vdout0_22ck990 FIND v(dout0_22) AT=1000.05n

.meas tran vdout0_23ck990 FIND v(dout0_23) AT=1000.05n

.meas tran vdout0_24ck990 FIND v(dout0_24) AT=1000.05n

.meas tran vdout0_25ck990 FIND v(dout0_25) AT=1000.05n

.meas tran vdout0_26ck990 FIND v(dout0_26) AT=1000.05n

.meas tran vdout0_27ck990 FIND v(dout0_27) AT=1000.05n

.meas tran vdout0_28ck990 FIND v(dout0_28) AT=1000.05n

.meas tran vdout0_29ck990 FIND v(dout0_29) AT=1000.05n

.meas tran vdout0_30ck990 FIND v(dout0_30) AT=1000.05n

.meas tran vdout0_31ck990 FIND v(dout0_31) AT=1000.05n

.meas tran vdout0_32ck990 FIND v(dout0_32) AT=1000.05n

.meas tran vdout0_0ck1010 FIND v(dout0_0) AT=1020.05n

.meas tran vdout0_1ck1010 FIND v(dout0_1) AT=1020.05n

.meas tran vdout0_2ck1010 FIND v(dout0_2) AT=1020.05n

.meas tran vdout0_3ck1010 FIND v(dout0_3) AT=1020.05n

.meas tran vdout0_4ck1010 FIND v(dout0_4) AT=1020.05n

.meas tran vdout0_5ck1010 FIND v(dout0_5) AT=1020.05n

.meas tran vdout0_6ck1010 FIND v(dout0_6) AT=1020.05n

.meas tran vdout0_7ck1010 FIND v(dout0_7) AT=1020.05n

.meas tran vdout0_8ck1010 FIND v(dout0_8) AT=1020.05n

.meas tran vdout0_9ck1010 FIND v(dout0_9) AT=1020.05n

.meas tran vdout0_10ck1010 FIND v(dout0_10) AT=1020.05n

.meas tran vdout0_11ck1010 FIND v(dout0_11) AT=1020.05n

.meas tran vdout0_12ck1010 FIND v(dout0_12) AT=1020.05n

.meas tran vdout0_13ck1010 FIND v(dout0_13) AT=1020.05n

.meas tran vdout0_14ck1010 FIND v(dout0_14) AT=1020.05n

.meas tran vdout0_15ck1010 FIND v(dout0_15) AT=1020.05n

.meas tran vdout0_16ck1010 FIND v(dout0_16) AT=1020.05n

.meas tran vdout0_17ck1010 FIND v(dout0_17) AT=1020.05n

.meas tran vdout0_18ck1010 FIND v(dout0_18) AT=1020.05n

.meas tran vdout0_19ck1010 FIND v(dout0_19) AT=1020.05n

.meas tran vdout0_20ck1010 FIND v(dout0_20) AT=1020.05n

.meas tran vdout0_21ck1010 FIND v(dout0_21) AT=1020.05n

.meas tran vdout0_22ck1010 FIND v(dout0_22) AT=1020.05n

.meas tran vdout0_23ck1010 FIND v(dout0_23) AT=1020.05n

.meas tran vdout0_24ck1010 FIND v(dout0_24) AT=1020.05n

.meas tran vdout0_25ck1010 FIND v(dout0_25) AT=1020.05n

.meas tran vdout0_26ck1010 FIND v(dout0_26) AT=1020.05n

.meas tran vdout0_27ck1010 FIND v(dout0_27) AT=1020.05n

.meas tran vdout0_28ck1010 FIND v(dout0_28) AT=1020.05n

.meas tran vdout0_29ck1010 FIND v(dout0_29) AT=1020.05n

.meas tran vdout0_30ck1010 FIND v(dout0_30) AT=1020.05n

.meas tran vdout0_31ck1010 FIND v(dout0_31) AT=1020.05n

.meas tran vdout0_32ck1010 FIND v(dout0_32) AT=1020.05n

.meas tran vdout0_0ck1040 FIND v(dout0_0) AT=1050.05n

.meas tran vdout0_1ck1040 FIND v(dout0_1) AT=1050.05n

.meas tran vdout0_2ck1040 FIND v(dout0_2) AT=1050.05n

.meas tran vdout0_3ck1040 FIND v(dout0_3) AT=1050.05n

.meas tran vdout0_4ck1040 FIND v(dout0_4) AT=1050.05n

.meas tran vdout0_5ck1040 FIND v(dout0_5) AT=1050.05n

.meas tran vdout0_6ck1040 FIND v(dout0_6) AT=1050.05n

.meas tran vdout0_7ck1040 FIND v(dout0_7) AT=1050.05n

.meas tran vdout0_8ck1040 FIND v(dout0_8) AT=1050.05n

.meas tran vdout0_9ck1040 FIND v(dout0_9) AT=1050.05n

.meas tran vdout0_10ck1040 FIND v(dout0_10) AT=1050.05n

.meas tran vdout0_11ck1040 FIND v(dout0_11) AT=1050.05n

.meas tran vdout0_12ck1040 FIND v(dout0_12) AT=1050.05n

.meas tran vdout0_13ck1040 FIND v(dout0_13) AT=1050.05n

.meas tran vdout0_14ck1040 FIND v(dout0_14) AT=1050.05n

.meas tran vdout0_15ck1040 FIND v(dout0_15) AT=1050.05n

.meas tran vdout0_16ck1040 FIND v(dout0_16) AT=1050.05n

.meas tran vdout0_17ck1040 FIND v(dout0_17) AT=1050.05n

.meas tran vdout0_18ck1040 FIND v(dout0_18) AT=1050.05n

.meas tran vdout0_19ck1040 FIND v(dout0_19) AT=1050.05n

.meas tran vdout0_20ck1040 FIND v(dout0_20) AT=1050.05n

.meas tran vdout0_21ck1040 FIND v(dout0_21) AT=1050.05n

.meas tran vdout0_22ck1040 FIND v(dout0_22) AT=1050.05n

.meas tran vdout0_23ck1040 FIND v(dout0_23) AT=1050.05n

.meas tran vdout0_24ck1040 FIND v(dout0_24) AT=1050.05n

.meas tran vdout0_25ck1040 FIND v(dout0_25) AT=1050.05n

.meas tran vdout0_26ck1040 FIND v(dout0_26) AT=1050.05n

.meas tran vdout0_27ck1040 FIND v(dout0_27) AT=1050.05n

.meas tran vdout0_28ck1040 FIND v(dout0_28) AT=1050.05n

.meas tran vdout0_29ck1040 FIND v(dout0_29) AT=1050.05n

.meas tran vdout0_30ck1040 FIND v(dout0_30) AT=1050.05n

.meas tran vdout0_31ck1040 FIND v(dout0_31) AT=1050.05n

.meas tran vdout0_32ck1040 FIND v(dout0_32) AT=1050.05n

.meas tran vdout0_0ck1090 FIND v(dout0_0) AT=1100.05n

.meas tran vdout0_1ck1090 FIND v(dout0_1) AT=1100.05n

.meas tran vdout0_2ck1090 FIND v(dout0_2) AT=1100.05n

.meas tran vdout0_3ck1090 FIND v(dout0_3) AT=1100.05n

.meas tran vdout0_4ck1090 FIND v(dout0_4) AT=1100.05n

.meas tran vdout0_5ck1090 FIND v(dout0_5) AT=1100.05n

.meas tran vdout0_6ck1090 FIND v(dout0_6) AT=1100.05n

.meas tran vdout0_7ck1090 FIND v(dout0_7) AT=1100.05n

.meas tran vdout0_8ck1090 FIND v(dout0_8) AT=1100.05n

.meas tran vdout0_9ck1090 FIND v(dout0_9) AT=1100.05n

.meas tran vdout0_10ck1090 FIND v(dout0_10) AT=1100.05n

.meas tran vdout0_11ck1090 FIND v(dout0_11) AT=1100.05n

.meas tran vdout0_12ck1090 FIND v(dout0_12) AT=1100.05n

.meas tran vdout0_13ck1090 FIND v(dout0_13) AT=1100.05n

.meas tran vdout0_14ck1090 FIND v(dout0_14) AT=1100.05n

.meas tran vdout0_15ck1090 FIND v(dout0_15) AT=1100.05n

.meas tran vdout0_16ck1090 FIND v(dout0_16) AT=1100.05n

.meas tran vdout0_17ck1090 FIND v(dout0_17) AT=1100.05n

.meas tran vdout0_18ck1090 FIND v(dout0_18) AT=1100.05n

.meas tran vdout0_19ck1090 FIND v(dout0_19) AT=1100.05n

.meas tran vdout0_20ck1090 FIND v(dout0_20) AT=1100.05n

.meas tran vdout0_21ck1090 FIND v(dout0_21) AT=1100.05n

.meas tran vdout0_22ck1090 FIND v(dout0_22) AT=1100.05n

.meas tran vdout0_23ck1090 FIND v(dout0_23) AT=1100.05n

.meas tran vdout0_24ck1090 FIND v(dout0_24) AT=1100.05n

.meas tran vdout0_25ck1090 FIND v(dout0_25) AT=1100.05n

.meas tran vdout0_26ck1090 FIND v(dout0_26) AT=1100.05n

.meas tran vdout0_27ck1090 FIND v(dout0_27) AT=1100.05n

.meas tran vdout0_28ck1090 FIND v(dout0_28) AT=1100.05n

.meas tran vdout0_29ck1090 FIND v(dout0_29) AT=1100.05n

.meas tran vdout0_30ck1090 FIND v(dout0_30) AT=1100.05n

.meas tran vdout0_31ck1090 FIND v(dout0_31) AT=1100.05n

.meas tran vdout0_32ck1090 FIND v(dout0_32) AT=1100.05n

.meas tran vdout0_0ck1110 FIND v(dout0_0) AT=1120.05n

.meas tran vdout0_1ck1110 FIND v(dout0_1) AT=1120.05n

.meas tran vdout0_2ck1110 FIND v(dout0_2) AT=1120.05n

.meas tran vdout0_3ck1110 FIND v(dout0_3) AT=1120.05n

.meas tran vdout0_4ck1110 FIND v(dout0_4) AT=1120.05n

.meas tran vdout0_5ck1110 FIND v(dout0_5) AT=1120.05n

.meas tran vdout0_6ck1110 FIND v(dout0_6) AT=1120.05n

.meas tran vdout0_7ck1110 FIND v(dout0_7) AT=1120.05n

.meas tran vdout0_8ck1110 FIND v(dout0_8) AT=1120.05n

.meas tran vdout0_9ck1110 FIND v(dout0_9) AT=1120.05n

.meas tran vdout0_10ck1110 FIND v(dout0_10) AT=1120.05n

.meas tran vdout0_11ck1110 FIND v(dout0_11) AT=1120.05n

.meas tran vdout0_12ck1110 FIND v(dout0_12) AT=1120.05n

.meas tran vdout0_13ck1110 FIND v(dout0_13) AT=1120.05n

.meas tran vdout0_14ck1110 FIND v(dout0_14) AT=1120.05n

.meas tran vdout0_15ck1110 FIND v(dout0_15) AT=1120.05n

.meas tran vdout0_16ck1110 FIND v(dout0_16) AT=1120.05n

.meas tran vdout0_17ck1110 FIND v(dout0_17) AT=1120.05n

.meas tran vdout0_18ck1110 FIND v(dout0_18) AT=1120.05n

.meas tran vdout0_19ck1110 FIND v(dout0_19) AT=1120.05n

.meas tran vdout0_20ck1110 FIND v(dout0_20) AT=1120.05n

.meas tran vdout0_21ck1110 FIND v(dout0_21) AT=1120.05n

.meas tran vdout0_22ck1110 FIND v(dout0_22) AT=1120.05n

.meas tran vdout0_23ck1110 FIND v(dout0_23) AT=1120.05n

.meas tran vdout0_24ck1110 FIND v(dout0_24) AT=1120.05n

.meas tran vdout0_25ck1110 FIND v(dout0_25) AT=1120.05n

.meas tran vdout0_26ck1110 FIND v(dout0_26) AT=1120.05n

.meas tran vdout0_27ck1110 FIND v(dout0_27) AT=1120.05n

.meas tran vdout0_28ck1110 FIND v(dout0_28) AT=1120.05n

.meas tran vdout0_29ck1110 FIND v(dout0_29) AT=1120.05n

.meas tran vdout0_30ck1110 FIND v(dout0_30) AT=1120.05n

.meas tran vdout0_31ck1110 FIND v(dout0_31) AT=1120.05n

.meas tran vdout0_32ck1110 FIND v(dout0_32) AT=1120.05n

.meas tran vdout0_0ck1140 FIND v(dout0_0) AT=1150.05n

.meas tran vdout0_1ck1140 FIND v(dout0_1) AT=1150.05n

.meas tran vdout0_2ck1140 FIND v(dout0_2) AT=1150.05n

.meas tran vdout0_3ck1140 FIND v(dout0_3) AT=1150.05n

.meas tran vdout0_4ck1140 FIND v(dout0_4) AT=1150.05n

.meas tran vdout0_5ck1140 FIND v(dout0_5) AT=1150.05n

.meas tran vdout0_6ck1140 FIND v(dout0_6) AT=1150.05n

.meas tran vdout0_7ck1140 FIND v(dout0_7) AT=1150.05n

.meas tran vdout0_8ck1140 FIND v(dout0_8) AT=1150.05n

.meas tran vdout0_9ck1140 FIND v(dout0_9) AT=1150.05n

.meas tran vdout0_10ck1140 FIND v(dout0_10) AT=1150.05n

.meas tran vdout0_11ck1140 FIND v(dout0_11) AT=1150.05n

.meas tran vdout0_12ck1140 FIND v(dout0_12) AT=1150.05n

.meas tran vdout0_13ck1140 FIND v(dout0_13) AT=1150.05n

.meas tran vdout0_14ck1140 FIND v(dout0_14) AT=1150.05n

.meas tran vdout0_15ck1140 FIND v(dout0_15) AT=1150.05n

.meas tran vdout0_16ck1140 FIND v(dout0_16) AT=1150.05n

.meas tran vdout0_17ck1140 FIND v(dout0_17) AT=1150.05n

.meas tran vdout0_18ck1140 FIND v(dout0_18) AT=1150.05n

.meas tran vdout0_19ck1140 FIND v(dout0_19) AT=1150.05n

.meas tran vdout0_20ck1140 FIND v(dout0_20) AT=1150.05n

.meas tran vdout0_21ck1140 FIND v(dout0_21) AT=1150.05n

.meas tran vdout0_22ck1140 FIND v(dout0_22) AT=1150.05n

.meas tran vdout0_23ck1140 FIND v(dout0_23) AT=1150.05n

.meas tran vdout0_24ck1140 FIND v(dout0_24) AT=1150.05n

.meas tran vdout0_25ck1140 FIND v(dout0_25) AT=1150.05n

.meas tran vdout0_26ck1140 FIND v(dout0_26) AT=1150.05n

.meas tran vdout0_27ck1140 FIND v(dout0_27) AT=1150.05n

.meas tran vdout0_28ck1140 FIND v(dout0_28) AT=1150.05n

.meas tran vdout0_29ck1140 FIND v(dout0_29) AT=1150.05n

.meas tran vdout0_30ck1140 FIND v(dout0_30) AT=1150.05n

.meas tran vdout0_31ck1140 FIND v(dout0_31) AT=1150.05n

.meas tran vdout0_32ck1140 FIND v(dout0_32) AT=1150.05n

.meas tran vdout0_0ck1170 FIND v(dout0_0) AT=1180.05n

.meas tran vdout0_1ck1170 FIND v(dout0_1) AT=1180.05n

.meas tran vdout0_2ck1170 FIND v(dout0_2) AT=1180.05n

.meas tran vdout0_3ck1170 FIND v(dout0_3) AT=1180.05n

.meas tran vdout0_4ck1170 FIND v(dout0_4) AT=1180.05n

.meas tran vdout0_5ck1170 FIND v(dout0_5) AT=1180.05n

.meas tran vdout0_6ck1170 FIND v(dout0_6) AT=1180.05n

.meas tran vdout0_7ck1170 FIND v(dout0_7) AT=1180.05n

.meas tran vdout0_8ck1170 FIND v(dout0_8) AT=1180.05n

.meas tran vdout0_9ck1170 FIND v(dout0_9) AT=1180.05n

.meas tran vdout0_10ck1170 FIND v(dout0_10) AT=1180.05n

.meas tran vdout0_11ck1170 FIND v(dout0_11) AT=1180.05n

.meas tran vdout0_12ck1170 FIND v(dout0_12) AT=1180.05n

.meas tran vdout0_13ck1170 FIND v(dout0_13) AT=1180.05n

.meas tran vdout0_14ck1170 FIND v(dout0_14) AT=1180.05n

.meas tran vdout0_15ck1170 FIND v(dout0_15) AT=1180.05n

.meas tran vdout0_16ck1170 FIND v(dout0_16) AT=1180.05n

.meas tran vdout0_17ck1170 FIND v(dout0_17) AT=1180.05n

.meas tran vdout0_18ck1170 FIND v(dout0_18) AT=1180.05n

.meas tran vdout0_19ck1170 FIND v(dout0_19) AT=1180.05n

.meas tran vdout0_20ck1170 FIND v(dout0_20) AT=1180.05n

.meas tran vdout0_21ck1170 FIND v(dout0_21) AT=1180.05n

.meas tran vdout0_22ck1170 FIND v(dout0_22) AT=1180.05n

.meas tran vdout0_23ck1170 FIND v(dout0_23) AT=1180.05n

.meas tran vdout0_24ck1170 FIND v(dout0_24) AT=1180.05n

.meas tran vdout0_25ck1170 FIND v(dout0_25) AT=1180.05n

.meas tran vdout0_26ck1170 FIND v(dout0_26) AT=1180.05n

.meas tran vdout0_27ck1170 FIND v(dout0_27) AT=1180.05n

.meas tran vdout0_28ck1170 FIND v(dout0_28) AT=1180.05n

.meas tran vdout0_29ck1170 FIND v(dout0_29) AT=1180.05n

.meas tran vdout0_30ck1170 FIND v(dout0_30) AT=1180.05n

.meas tran vdout0_31ck1170 FIND v(dout0_31) AT=1180.05n

.meas tran vdout0_32ck1170 FIND v(dout0_32) AT=1180.05n

.meas tran vdout0_0ck1180 FIND v(dout0_0) AT=1190.05n

.meas tran vdout0_1ck1180 FIND v(dout0_1) AT=1190.05n

.meas tran vdout0_2ck1180 FIND v(dout0_2) AT=1190.05n

.meas tran vdout0_3ck1180 FIND v(dout0_3) AT=1190.05n

.meas tran vdout0_4ck1180 FIND v(dout0_4) AT=1190.05n

.meas tran vdout0_5ck1180 FIND v(dout0_5) AT=1190.05n

.meas tran vdout0_6ck1180 FIND v(dout0_6) AT=1190.05n

.meas tran vdout0_7ck1180 FIND v(dout0_7) AT=1190.05n

.meas tran vdout0_8ck1180 FIND v(dout0_8) AT=1190.05n

.meas tran vdout0_9ck1180 FIND v(dout0_9) AT=1190.05n

.meas tran vdout0_10ck1180 FIND v(dout0_10) AT=1190.05n

.meas tran vdout0_11ck1180 FIND v(dout0_11) AT=1190.05n

.meas tran vdout0_12ck1180 FIND v(dout0_12) AT=1190.05n

.meas tran vdout0_13ck1180 FIND v(dout0_13) AT=1190.05n

.meas tran vdout0_14ck1180 FIND v(dout0_14) AT=1190.05n

.meas tran vdout0_15ck1180 FIND v(dout0_15) AT=1190.05n

.meas tran vdout0_16ck1180 FIND v(dout0_16) AT=1190.05n

.meas tran vdout0_17ck1180 FIND v(dout0_17) AT=1190.05n

.meas tran vdout0_18ck1180 FIND v(dout0_18) AT=1190.05n

.meas tran vdout0_19ck1180 FIND v(dout0_19) AT=1190.05n

.meas tran vdout0_20ck1180 FIND v(dout0_20) AT=1190.05n

.meas tran vdout0_21ck1180 FIND v(dout0_21) AT=1190.05n

.meas tran vdout0_22ck1180 FIND v(dout0_22) AT=1190.05n

.meas tran vdout0_23ck1180 FIND v(dout0_23) AT=1190.05n

.meas tran vdout0_24ck1180 FIND v(dout0_24) AT=1190.05n

.meas tran vdout0_25ck1180 FIND v(dout0_25) AT=1190.05n

.meas tran vdout0_26ck1180 FIND v(dout0_26) AT=1190.05n

.meas tran vdout0_27ck1180 FIND v(dout0_27) AT=1190.05n

.meas tran vdout0_28ck1180 FIND v(dout0_28) AT=1190.05n

.meas tran vdout0_29ck1180 FIND v(dout0_29) AT=1190.05n

.meas tran vdout0_30ck1180 FIND v(dout0_30) AT=1190.05n

.meas tran vdout0_31ck1180 FIND v(dout0_31) AT=1190.05n

.meas tran vdout0_32ck1180 FIND v(dout0_32) AT=1190.05n

.meas tran vdout0_0ck1190 FIND v(dout0_0) AT=1200.05n

.meas tran vdout0_1ck1190 FIND v(dout0_1) AT=1200.05n

.meas tran vdout0_2ck1190 FIND v(dout0_2) AT=1200.05n

.meas tran vdout0_3ck1190 FIND v(dout0_3) AT=1200.05n

.meas tran vdout0_4ck1190 FIND v(dout0_4) AT=1200.05n

.meas tran vdout0_5ck1190 FIND v(dout0_5) AT=1200.05n

.meas tran vdout0_6ck1190 FIND v(dout0_6) AT=1200.05n

.meas tran vdout0_7ck1190 FIND v(dout0_7) AT=1200.05n

.meas tran vdout0_8ck1190 FIND v(dout0_8) AT=1200.05n

.meas tran vdout0_9ck1190 FIND v(dout0_9) AT=1200.05n

.meas tran vdout0_10ck1190 FIND v(dout0_10) AT=1200.05n

.meas tran vdout0_11ck1190 FIND v(dout0_11) AT=1200.05n

.meas tran vdout0_12ck1190 FIND v(dout0_12) AT=1200.05n

.meas tran vdout0_13ck1190 FIND v(dout0_13) AT=1200.05n

.meas tran vdout0_14ck1190 FIND v(dout0_14) AT=1200.05n

.meas tran vdout0_15ck1190 FIND v(dout0_15) AT=1200.05n

.meas tran vdout0_16ck1190 FIND v(dout0_16) AT=1200.05n

.meas tran vdout0_17ck1190 FIND v(dout0_17) AT=1200.05n

.meas tran vdout0_18ck1190 FIND v(dout0_18) AT=1200.05n

.meas tran vdout0_19ck1190 FIND v(dout0_19) AT=1200.05n

.meas tran vdout0_20ck1190 FIND v(dout0_20) AT=1200.05n

.meas tran vdout0_21ck1190 FIND v(dout0_21) AT=1200.05n

.meas tran vdout0_22ck1190 FIND v(dout0_22) AT=1200.05n

.meas tran vdout0_23ck1190 FIND v(dout0_23) AT=1200.05n

.meas tran vdout0_24ck1190 FIND v(dout0_24) AT=1200.05n

.meas tran vdout0_25ck1190 FIND v(dout0_25) AT=1200.05n

.meas tran vdout0_26ck1190 FIND v(dout0_26) AT=1200.05n

.meas tran vdout0_27ck1190 FIND v(dout0_27) AT=1200.05n

.meas tran vdout0_28ck1190 FIND v(dout0_28) AT=1200.05n

.meas tran vdout0_29ck1190 FIND v(dout0_29) AT=1200.05n

.meas tran vdout0_30ck1190 FIND v(dout0_30) AT=1200.05n

.meas tran vdout0_31ck1190 FIND v(dout0_31) AT=1200.05n

.meas tran vdout0_32ck1190 FIND v(dout0_32) AT=1200.05n

.meas tran vdout0_0ck1210 FIND v(dout0_0) AT=1220.05n

.meas tran vdout0_1ck1210 FIND v(dout0_1) AT=1220.05n

.meas tran vdout0_2ck1210 FIND v(dout0_2) AT=1220.05n

.meas tran vdout0_3ck1210 FIND v(dout0_3) AT=1220.05n

.meas tran vdout0_4ck1210 FIND v(dout0_4) AT=1220.05n

.meas tran vdout0_5ck1210 FIND v(dout0_5) AT=1220.05n

.meas tran vdout0_6ck1210 FIND v(dout0_6) AT=1220.05n

.meas tran vdout0_7ck1210 FIND v(dout0_7) AT=1220.05n

.meas tran vdout0_8ck1210 FIND v(dout0_8) AT=1220.05n

.meas tran vdout0_9ck1210 FIND v(dout0_9) AT=1220.05n

.meas tran vdout0_10ck1210 FIND v(dout0_10) AT=1220.05n

.meas tran vdout0_11ck1210 FIND v(dout0_11) AT=1220.05n

.meas tran vdout0_12ck1210 FIND v(dout0_12) AT=1220.05n

.meas tran vdout0_13ck1210 FIND v(dout0_13) AT=1220.05n

.meas tran vdout0_14ck1210 FIND v(dout0_14) AT=1220.05n

.meas tran vdout0_15ck1210 FIND v(dout0_15) AT=1220.05n

.meas tran vdout0_16ck1210 FIND v(dout0_16) AT=1220.05n

.meas tran vdout0_17ck1210 FIND v(dout0_17) AT=1220.05n

.meas tran vdout0_18ck1210 FIND v(dout0_18) AT=1220.05n

.meas tran vdout0_19ck1210 FIND v(dout0_19) AT=1220.05n

.meas tran vdout0_20ck1210 FIND v(dout0_20) AT=1220.05n

.meas tran vdout0_21ck1210 FIND v(dout0_21) AT=1220.05n

.meas tran vdout0_22ck1210 FIND v(dout0_22) AT=1220.05n

.meas tran vdout0_23ck1210 FIND v(dout0_23) AT=1220.05n

.meas tran vdout0_24ck1210 FIND v(dout0_24) AT=1220.05n

.meas tran vdout0_25ck1210 FIND v(dout0_25) AT=1220.05n

.meas tran vdout0_26ck1210 FIND v(dout0_26) AT=1220.05n

.meas tran vdout0_27ck1210 FIND v(dout0_27) AT=1220.05n

.meas tran vdout0_28ck1210 FIND v(dout0_28) AT=1220.05n

.meas tran vdout0_29ck1210 FIND v(dout0_29) AT=1220.05n

.meas tran vdout0_30ck1210 FIND v(dout0_30) AT=1220.05n

.meas tran vdout0_31ck1210 FIND v(dout0_31) AT=1220.05n

.meas tran vdout0_32ck1210 FIND v(dout0_32) AT=1220.05n

.meas tran vdout0_0ck1230 FIND v(dout0_0) AT=1240.05n

.meas tran vdout0_1ck1230 FIND v(dout0_1) AT=1240.05n

.meas tran vdout0_2ck1230 FIND v(dout0_2) AT=1240.05n

.meas tran vdout0_3ck1230 FIND v(dout0_3) AT=1240.05n

.meas tran vdout0_4ck1230 FIND v(dout0_4) AT=1240.05n

.meas tran vdout0_5ck1230 FIND v(dout0_5) AT=1240.05n

.meas tran vdout0_6ck1230 FIND v(dout0_6) AT=1240.05n

.meas tran vdout0_7ck1230 FIND v(dout0_7) AT=1240.05n

.meas tran vdout0_8ck1230 FIND v(dout0_8) AT=1240.05n

.meas tran vdout0_9ck1230 FIND v(dout0_9) AT=1240.05n

.meas tran vdout0_10ck1230 FIND v(dout0_10) AT=1240.05n

.meas tran vdout0_11ck1230 FIND v(dout0_11) AT=1240.05n

.meas tran vdout0_12ck1230 FIND v(dout0_12) AT=1240.05n

.meas tran vdout0_13ck1230 FIND v(dout0_13) AT=1240.05n

.meas tran vdout0_14ck1230 FIND v(dout0_14) AT=1240.05n

.meas tran vdout0_15ck1230 FIND v(dout0_15) AT=1240.05n

.meas tran vdout0_16ck1230 FIND v(dout0_16) AT=1240.05n

.meas tran vdout0_17ck1230 FIND v(dout0_17) AT=1240.05n

.meas tran vdout0_18ck1230 FIND v(dout0_18) AT=1240.05n

.meas tran vdout0_19ck1230 FIND v(dout0_19) AT=1240.05n

.meas tran vdout0_20ck1230 FIND v(dout0_20) AT=1240.05n

.meas tran vdout0_21ck1230 FIND v(dout0_21) AT=1240.05n

.meas tran vdout0_22ck1230 FIND v(dout0_22) AT=1240.05n

.meas tran vdout0_23ck1230 FIND v(dout0_23) AT=1240.05n

.meas tran vdout0_24ck1230 FIND v(dout0_24) AT=1240.05n

.meas tran vdout0_25ck1230 FIND v(dout0_25) AT=1240.05n

.meas tran vdout0_26ck1230 FIND v(dout0_26) AT=1240.05n

.meas tran vdout0_27ck1230 FIND v(dout0_27) AT=1240.05n

.meas tran vdout0_28ck1230 FIND v(dout0_28) AT=1240.05n

.meas tran vdout0_29ck1230 FIND v(dout0_29) AT=1240.05n

.meas tran vdout0_30ck1230 FIND v(dout0_30) AT=1240.05n

.meas tran vdout0_31ck1230 FIND v(dout0_31) AT=1240.05n

.meas tran vdout0_32ck1230 FIND v(dout0_32) AT=1240.05n

.meas tran vdout0_0ck1240 FIND v(dout0_0) AT=1250.05n

.meas tran vdout0_1ck1240 FIND v(dout0_1) AT=1250.05n

.meas tran vdout0_2ck1240 FIND v(dout0_2) AT=1250.05n

.meas tran vdout0_3ck1240 FIND v(dout0_3) AT=1250.05n

.meas tran vdout0_4ck1240 FIND v(dout0_4) AT=1250.05n

.meas tran vdout0_5ck1240 FIND v(dout0_5) AT=1250.05n

.meas tran vdout0_6ck1240 FIND v(dout0_6) AT=1250.05n

.meas tran vdout0_7ck1240 FIND v(dout0_7) AT=1250.05n

.meas tran vdout0_8ck1240 FIND v(dout0_8) AT=1250.05n

.meas tran vdout0_9ck1240 FIND v(dout0_9) AT=1250.05n

.meas tran vdout0_10ck1240 FIND v(dout0_10) AT=1250.05n

.meas tran vdout0_11ck1240 FIND v(dout0_11) AT=1250.05n

.meas tran vdout0_12ck1240 FIND v(dout0_12) AT=1250.05n

.meas tran vdout0_13ck1240 FIND v(dout0_13) AT=1250.05n

.meas tran vdout0_14ck1240 FIND v(dout0_14) AT=1250.05n

.meas tran vdout0_15ck1240 FIND v(dout0_15) AT=1250.05n

.meas tran vdout0_16ck1240 FIND v(dout0_16) AT=1250.05n

.meas tran vdout0_17ck1240 FIND v(dout0_17) AT=1250.05n

.meas tran vdout0_18ck1240 FIND v(dout0_18) AT=1250.05n

.meas tran vdout0_19ck1240 FIND v(dout0_19) AT=1250.05n

.meas tran vdout0_20ck1240 FIND v(dout0_20) AT=1250.05n

.meas tran vdout0_21ck1240 FIND v(dout0_21) AT=1250.05n

.meas tran vdout0_22ck1240 FIND v(dout0_22) AT=1250.05n

.meas tran vdout0_23ck1240 FIND v(dout0_23) AT=1250.05n

.meas tran vdout0_24ck1240 FIND v(dout0_24) AT=1250.05n

.meas tran vdout0_25ck1240 FIND v(dout0_25) AT=1250.05n

.meas tran vdout0_26ck1240 FIND v(dout0_26) AT=1250.05n

.meas tran vdout0_27ck1240 FIND v(dout0_27) AT=1250.05n

.meas tran vdout0_28ck1240 FIND v(dout0_28) AT=1250.05n

.meas tran vdout0_29ck1240 FIND v(dout0_29) AT=1250.05n

.meas tran vdout0_30ck1240 FIND v(dout0_30) AT=1250.05n

.meas tran vdout0_31ck1240 FIND v(dout0_31) AT=1250.05n

.meas tran vdout0_32ck1240 FIND v(dout0_32) AT=1250.05n

.meas tran vdout0_0ck1300 FIND v(dout0_0) AT=1310.05n

.meas tran vdout0_1ck1300 FIND v(dout0_1) AT=1310.05n

.meas tran vdout0_2ck1300 FIND v(dout0_2) AT=1310.05n

.meas tran vdout0_3ck1300 FIND v(dout0_3) AT=1310.05n

.meas tran vdout0_4ck1300 FIND v(dout0_4) AT=1310.05n

.meas tran vdout0_5ck1300 FIND v(dout0_5) AT=1310.05n

.meas tran vdout0_6ck1300 FIND v(dout0_6) AT=1310.05n

.meas tran vdout0_7ck1300 FIND v(dout0_7) AT=1310.05n

.meas tran vdout0_8ck1300 FIND v(dout0_8) AT=1310.05n

.meas tran vdout0_9ck1300 FIND v(dout0_9) AT=1310.05n

.meas tran vdout0_10ck1300 FIND v(dout0_10) AT=1310.05n

.meas tran vdout0_11ck1300 FIND v(dout0_11) AT=1310.05n

.meas tran vdout0_12ck1300 FIND v(dout0_12) AT=1310.05n

.meas tran vdout0_13ck1300 FIND v(dout0_13) AT=1310.05n

.meas tran vdout0_14ck1300 FIND v(dout0_14) AT=1310.05n

.meas tran vdout0_15ck1300 FIND v(dout0_15) AT=1310.05n

.meas tran vdout0_16ck1300 FIND v(dout0_16) AT=1310.05n

.meas tran vdout0_17ck1300 FIND v(dout0_17) AT=1310.05n

.meas tran vdout0_18ck1300 FIND v(dout0_18) AT=1310.05n

.meas tran vdout0_19ck1300 FIND v(dout0_19) AT=1310.05n

.meas tran vdout0_20ck1300 FIND v(dout0_20) AT=1310.05n

.meas tran vdout0_21ck1300 FIND v(dout0_21) AT=1310.05n

.meas tran vdout0_22ck1300 FIND v(dout0_22) AT=1310.05n

.meas tran vdout0_23ck1300 FIND v(dout0_23) AT=1310.05n

.meas tran vdout0_24ck1300 FIND v(dout0_24) AT=1310.05n

.meas tran vdout0_25ck1300 FIND v(dout0_25) AT=1310.05n

.meas tran vdout0_26ck1300 FIND v(dout0_26) AT=1310.05n

.meas tran vdout0_27ck1300 FIND v(dout0_27) AT=1310.05n

.meas tran vdout0_28ck1300 FIND v(dout0_28) AT=1310.05n

.meas tran vdout0_29ck1300 FIND v(dout0_29) AT=1310.05n

.meas tran vdout0_30ck1300 FIND v(dout0_30) AT=1310.05n

.meas tran vdout0_31ck1300 FIND v(dout0_31) AT=1310.05n

.meas tran vdout0_32ck1300 FIND v(dout0_32) AT=1310.05n

.meas tran vdout0_0ck1310 FIND v(dout0_0) AT=1320.05n

.meas tran vdout0_1ck1310 FIND v(dout0_1) AT=1320.05n

.meas tran vdout0_2ck1310 FIND v(dout0_2) AT=1320.05n

.meas tran vdout0_3ck1310 FIND v(dout0_3) AT=1320.05n

.meas tran vdout0_4ck1310 FIND v(dout0_4) AT=1320.05n

.meas tran vdout0_5ck1310 FIND v(dout0_5) AT=1320.05n

.meas tran vdout0_6ck1310 FIND v(dout0_6) AT=1320.05n

.meas tran vdout0_7ck1310 FIND v(dout0_7) AT=1320.05n

.meas tran vdout0_8ck1310 FIND v(dout0_8) AT=1320.05n

.meas tran vdout0_9ck1310 FIND v(dout0_9) AT=1320.05n

.meas tran vdout0_10ck1310 FIND v(dout0_10) AT=1320.05n

.meas tran vdout0_11ck1310 FIND v(dout0_11) AT=1320.05n

.meas tran vdout0_12ck1310 FIND v(dout0_12) AT=1320.05n

.meas tran vdout0_13ck1310 FIND v(dout0_13) AT=1320.05n

.meas tran vdout0_14ck1310 FIND v(dout0_14) AT=1320.05n

.meas tran vdout0_15ck1310 FIND v(dout0_15) AT=1320.05n

.meas tran vdout0_16ck1310 FIND v(dout0_16) AT=1320.05n

.meas tran vdout0_17ck1310 FIND v(dout0_17) AT=1320.05n

.meas tran vdout0_18ck1310 FIND v(dout0_18) AT=1320.05n

.meas tran vdout0_19ck1310 FIND v(dout0_19) AT=1320.05n

.meas tran vdout0_20ck1310 FIND v(dout0_20) AT=1320.05n

.meas tran vdout0_21ck1310 FIND v(dout0_21) AT=1320.05n

.meas tran vdout0_22ck1310 FIND v(dout0_22) AT=1320.05n

.meas tran vdout0_23ck1310 FIND v(dout0_23) AT=1320.05n

.meas tran vdout0_24ck1310 FIND v(dout0_24) AT=1320.05n

.meas tran vdout0_25ck1310 FIND v(dout0_25) AT=1320.05n

.meas tran vdout0_26ck1310 FIND v(dout0_26) AT=1320.05n

.meas tran vdout0_27ck1310 FIND v(dout0_27) AT=1320.05n

.meas tran vdout0_28ck1310 FIND v(dout0_28) AT=1320.05n

.meas tran vdout0_29ck1310 FIND v(dout0_29) AT=1320.05n

.meas tran vdout0_30ck1310 FIND v(dout0_30) AT=1320.05n

.meas tran vdout0_31ck1310 FIND v(dout0_31) AT=1320.05n

.meas tran vdout0_32ck1310 FIND v(dout0_32) AT=1320.05n

.meas tran vdout0_0ck1340 FIND v(dout0_0) AT=1350.05n

.meas tran vdout0_1ck1340 FIND v(dout0_1) AT=1350.05n

.meas tran vdout0_2ck1340 FIND v(dout0_2) AT=1350.05n

.meas tran vdout0_3ck1340 FIND v(dout0_3) AT=1350.05n

.meas tran vdout0_4ck1340 FIND v(dout0_4) AT=1350.05n

.meas tran vdout0_5ck1340 FIND v(dout0_5) AT=1350.05n

.meas tran vdout0_6ck1340 FIND v(dout0_6) AT=1350.05n

.meas tran vdout0_7ck1340 FIND v(dout0_7) AT=1350.05n

.meas tran vdout0_8ck1340 FIND v(dout0_8) AT=1350.05n

.meas tran vdout0_9ck1340 FIND v(dout0_9) AT=1350.05n

.meas tran vdout0_10ck1340 FIND v(dout0_10) AT=1350.05n

.meas tran vdout0_11ck1340 FIND v(dout0_11) AT=1350.05n

.meas tran vdout0_12ck1340 FIND v(dout0_12) AT=1350.05n

.meas tran vdout0_13ck1340 FIND v(dout0_13) AT=1350.05n

.meas tran vdout0_14ck1340 FIND v(dout0_14) AT=1350.05n

.meas tran vdout0_15ck1340 FIND v(dout0_15) AT=1350.05n

.meas tran vdout0_16ck1340 FIND v(dout0_16) AT=1350.05n

.meas tran vdout0_17ck1340 FIND v(dout0_17) AT=1350.05n

.meas tran vdout0_18ck1340 FIND v(dout0_18) AT=1350.05n

.meas tran vdout0_19ck1340 FIND v(dout0_19) AT=1350.05n

.meas tran vdout0_20ck1340 FIND v(dout0_20) AT=1350.05n

.meas tran vdout0_21ck1340 FIND v(dout0_21) AT=1350.05n

.meas tran vdout0_22ck1340 FIND v(dout0_22) AT=1350.05n

.meas tran vdout0_23ck1340 FIND v(dout0_23) AT=1350.05n

.meas tran vdout0_24ck1340 FIND v(dout0_24) AT=1350.05n

.meas tran vdout0_25ck1340 FIND v(dout0_25) AT=1350.05n

.meas tran vdout0_26ck1340 FIND v(dout0_26) AT=1350.05n

.meas tran vdout0_27ck1340 FIND v(dout0_27) AT=1350.05n

.meas tran vdout0_28ck1340 FIND v(dout0_28) AT=1350.05n

.meas tran vdout0_29ck1340 FIND v(dout0_29) AT=1350.05n

.meas tran vdout0_30ck1340 FIND v(dout0_30) AT=1350.05n

.meas tran vdout0_31ck1340 FIND v(dout0_31) AT=1350.05n

.meas tran vdout0_32ck1340 FIND v(dout0_32) AT=1350.05n

.meas tran vdout0_0ck1350 FIND v(dout0_0) AT=1360.05n

.meas tran vdout0_1ck1350 FIND v(dout0_1) AT=1360.05n

.meas tran vdout0_2ck1350 FIND v(dout0_2) AT=1360.05n

.meas tran vdout0_3ck1350 FIND v(dout0_3) AT=1360.05n

.meas tran vdout0_4ck1350 FIND v(dout0_4) AT=1360.05n

.meas tran vdout0_5ck1350 FIND v(dout0_5) AT=1360.05n

.meas tran vdout0_6ck1350 FIND v(dout0_6) AT=1360.05n

.meas tran vdout0_7ck1350 FIND v(dout0_7) AT=1360.05n

.meas tran vdout0_8ck1350 FIND v(dout0_8) AT=1360.05n

.meas tran vdout0_9ck1350 FIND v(dout0_9) AT=1360.05n

.meas tran vdout0_10ck1350 FIND v(dout0_10) AT=1360.05n

.meas tran vdout0_11ck1350 FIND v(dout0_11) AT=1360.05n

.meas tran vdout0_12ck1350 FIND v(dout0_12) AT=1360.05n

.meas tran vdout0_13ck1350 FIND v(dout0_13) AT=1360.05n

.meas tran vdout0_14ck1350 FIND v(dout0_14) AT=1360.05n

.meas tran vdout0_15ck1350 FIND v(dout0_15) AT=1360.05n

.meas tran vdout0_16ck1350 FIND v(dout0_16) AT=1360.05n

.meas tran vdout0_17ck1350 FIND v(dout0_17) AT=1360.05n

.meas tran vdout0_18ck1350 FIND v(dout0_18) AT=1360.05n

.meas tran vdout0_19ck1350 FIND v(dout0_19) AT=1360.05n

.meas tran vdout0_20ck1350 FIND v(dout0_20) AT=1360.05n

.meas tran vdout0_21ck1350 FIND v(dout0_21) AT=1360.05n

.meas tran vdout0_22ck1350 FIND v(dout0_22) AT=1360.05n

.meas tran vdout0_23ck1350 FIND v(dout0_23) AT=1360.05n

.meas tran vdout0_24ck1350 FIND v(dout0_24) AT=1360.05n

.meas tran vdout0_25ck1350 FIND v(dout0_25) AT=1360.05n

.meas tran vdout0_26ck1350 FIND v(dout0_26) AT=1360.05n

.meas tran vdout0_27ck1350 FIND v(dout0_27) AT=1360.05n

.meas tran vdout0_28ck1350 FIND v(dout0_28) AT=1360.05n

.meas tran vdout0_29ck1350 FIND v(dout0_29) AT=1360.05n

.meas tran vdout0_30ck1350 FIND v(dout0_30) AT=1360.05n

.meas tran vdout0_31ck1350 FIND v(dout0_31) AT=1360.05n

.meas tran vdout0_32ck1350 FIND v(dout0_32) AT=1360.05n

.meas tran vdout0_0ck1380 FIND v(dout0_0) AT=1390.05n

.meas tran vdout0_1ck1380 FIND v(dout0_1) AT=1390.05n

.meas tran vdout0_2ck1380 FIND v(dout0_2) AT=1390.05n

.meas tran vdout0_3ck1380 FIND v(dout0_3) AT=1390.05n

.meas tran vdout0_4ck1380 FIND v(dout0_4) AT=1390.05n

.meas tran vdout0_5ck1380 FIND v(dout0_5) AT=1390.05n

.meas tran vdout0_6ck1380 FIND v(dout0_6) AT=1390.05n

.meas tran vdout0_7ck1380 FIND v(dout0_7) AT=1390.05n

.meas tran vdout0_8ck1380 FIND v(dout0_8) AT=1390.05n

.meas tran vdout0_9ck1380 FIND v(dout0_9) AT=1390.05n

.meas tran vdout0_10ck1380 FIND v(dout0_10) AT=1390.05n

.meas tran vdout0_11ck1380 FIND v(dout0_11) AT=1390.05n

.meas tran vdout0_12ck1380 FIND v(dout0_12) AT=1390.05n

.meas tran vdout0_13ck1380 FIND v(dout0_13) AT=1390.05n

.meas tran vdout0_14ck1380 FIND v(dout0_14) AT=1390.05n

.meas tran vdout0_15ck1380 FIND v(dout0_15) AT=1390.05n

.meas tran vdout0_16ck1380 FIND v(dout0_16) AT=1390.05n

.meas tran vdout0_17ck1380 FIND v(dout0_17) AT=1390.05n

.meas tran vdout0_18ck1380 FIND v(dout0_18) AT=1390.05n

.meas tran vdout0_19ck1380 FIND v(dout0_19) AT=1390.05n

.meas tran vdout0_20ck1380 FIND v(dout0_20) AT=1390.05n

.meas tran vdout0_21ck1380 FIND v(dout0_21) AT=1390.05n

.meas tran vdout0_22ck1380 FIND v(dout0_22) AT=1390.05n

.meas tran vdout0_23ck1380 FIND v(dout0_23) AT=1390.05n

.meas tran vdout0_24ck1380 FIND v(dout0_24) AT=1390.05n

.meas tran vdout0_25ck1380 FIND v(dout0_25) AT=1390.05n

.meas tran vdout0_26ck1380 FIND v(dout0_26) AT=1390.05n

.meas tran vdout0_27ck1380 FIND v(dout0_27) AT=1390.05n

.meas tran vdout0_28ck1380 FIND v(dout0_28) AT=1390.05n

.meas tran vdout0_29ck1380 FIND v(dout0_29) AT=1390.05n

.meas tran vdout0_30ck1380 FIND v(dout0_30) AT=1390.05n

.meas tran vdout0_31ck1380 FIND v(dout0_31) AT=1390.05n

.meas tran vdout0_32ck1380 FIND v(dout0_32) AT=1390.05n

.meas tran vdout0_0ck1400 FIND v(dout0_0) AT=1410.05n

.meas tran vdout0_1ck1400 FIND v(dout0_1) AT=1410.05n

.meas tran vdout0_2ck1400 FIND v(dout0_2) AT=1410.05n

.meas tran vdout0_3ck1400 FIND v(dout0_3) AT=1410.05n

.meas tran vdout0_4ck1400 FIND v(dout0_4) AT=1410.05n

.meas tran vdout0_5ck1400 FIND v(dout0_5) AT=1410.05n

.meas tran vdout0_6ck1400 FIND v(dout0_6) AT=1410.05n

.meas tran vdout0_7ck1400 FIND v(dout0_7) AT=1410.05n

.meas tran vdout0_8ck1400 FIND v(dout0_8) AT=1410.05n

.meas tran vdout0_9ck1400 FIND v(dout0_9) AT=1410.05n

.meas tran vdout0_10ck1400 FIND v(dout0_10) AT=1410.05n

.meas tran vdout0_11ck1400 FIND v(dout0_11) AT=1410.05n

.meas tran vdout0_12ck1400 FIND v(dout0_12) AT=1410.05n

.meas tran vdout0_13ck1400 FIND v(dout0_13) AT=1410.05n

.meas tran vdout0_14ck1400 FIND v(dout0_14) AT=1410.05n

.meas tran vdout0_15ck1400 FIND v(dout0_15) AT=1410.05n

.meas tran vdout0_16ck1400 FIND v(dout0_16) AT=1410.05n

.meas tran vdout0_17ck1400 FIND v(dout0_17) AT=1410.05n

.meas tran vdout0_18ck1400 FIND v(dout0_18) AT=1410.05n

.meas tran vdout0_19ck1400 FIND v(dout0_19) AT=1410.05n

.meas tran vdout0_20ck1400 FIND v(dout0_20) AT=1410.05n

.meas tran vdout0_21ck1400 FIND v(dout0_21) AT=1410.05n

.meas tran vdout0_22ck1400 FIND v(dout0_22) AT=1410.05n

.meas tran vdout0_23ck1400 FIND v(dout0_23) AT=1410.05n

.meas tran vdout0_24ck1400 FIND v(dout0_24) AT=1410.05n

.meas tran vdout0_25ck1400 FIND v(dout0_25) AT=1410.05n

.meas tran vdout0_26ck1400 FIND v(dout0_26) AT=1410.05n

.meas tran vdout0_27ck1400 FIND v(dout0_27) AT=1410.05n

.meas tran vdout0_28ck1400 FIND v(dout0_28) AT=1410.05n

.meas tran vdout0_29ck1400 FIND v(dout0_29) AT=1410.05n

.meas tran vdout0_30ck1400 FIND v(dout0_30) AT=1410.05n

.meas tran vdout0_31ck1400 FIND v(dout0_31) AT=1410.05n

.meas tran vdout0_32ck1400 FIND v(dout0_32) AT=1410.05n

.meas tran vdout0_0ck1410 FIND v(dout0_0) AT=1420.05n

.meas tran vdout0_1ck1410 FIND v(dout0_1) AT=1420.05n

.meas tran vdout0_2ck1410 FIND v(dout0_2) AT=1420.05n

.meas tran vdout0_3ck1410 FIND v(dout0_3) AT=1420.05n

.meas tran vdout0_4ck1410 FIND v(dout0_4) AT=1420.05n

.meas tran vdout0_5ck1410 FIND v(dout0_5) AT=1420.05n

.meas tran vdout0_6ck1410 FIND v(dout0_6) AT=1420.05n

.meas tran vdout0_7ck1410 FIND v(dout0_7) AT=1420.05n

.meas tran vdout0_8ck1410 FIND v(dout0_8) AT=1420.05n

.meas tran vdout0_9ck1410 FIND v(dout0_9) AT=1420.05n

.meas tran vdout0_10ck1410 FIND v(dout0_10) AT=1420.05n

.meas tran vdout0_11ck1410 FIND v(dout0_11) AT=1420.05n

.meas tran vdout0_12ck1410 FIND v(dout0_12) AT=1420.05n

.meas tran vdout0_13ck1410 FIND v(dout0_13) AT=1420.05n

.meas tran vdout0_14ck1410 FIND v(dout0_14) AT=1420.05n

.meas tran vdout0_15ck1410 FIND v(dout0_15) AT=1420.05n

.meas tran vdout0_16ck1410 FIND v(dout0_16) AT=1420.05n

.meas tran vdout0_17ck1410 FIND v(dout0_17) AT=1420.05n

.meas tran vdout0_18ck1410 FIND v(dout0_18) AT=1420.05n

.meas tran vdout0_19ck1410 FIND v(dout0_19) AT=1420.05n

.meas tran vdout0_20ck1410 FIND v(dout0_20) AT=1420.05n

.meas tran vdout0_21ck1410 FIND v(dout0_21) AT=1420.05n

.meas tran vdout0_22ck1410 FIND v(dout0_22) AT=1420.05n

.meas tran vdout0_23ck1410 FIND v(dout0_23) AT=1420.05n

.meas tran vdout0_24ck1410 FIND v(dout0_24) AT=1420.05n

.meas tran vdout0_25ck1410 FIND v(dout0_25) AT=1420.05n

.meas tran vdout0_26ck1410 FIND v(dout0_26) AT=1420.05n

.meas tran vdout0_27ck1410 FIND v(dout0_27) AT=1420.05n

.meas tran vdout0_28ck1410 FIND v(dout0_28) AT=1420.05n

.meas tran vdout0_29ck1410 FIND v(dout0_29) AT=1420.05n

.meas tran vdout0_30ck1410 FIND v(dout0_30) AT=1420.05n

.meas tran vdout0_31ck1410 FIND v(dout0_31) AT=1420.05n

.meas tran vdout0_32ck1410 FIND v(dout0_32) AT=1420.05n

.meas tran vdout0_0ck1420 FIND v(dout0_0) AT=1430.05n

.meas tran vdout0_1ck1420 FIND v(dout0_1) AT=1430.05n

.meas tran vdout0_2ck1420 FIND v(dout0_2) AT=1430.05n

.meas tran vdout0_3ck1420 FIND v(dout0_3) AT=1430.05n

.meas tran vdout0_4ck1420 FIND v(dout0_4) AT=1430.05n

.meas tran vdout0_5ck1420 FIND v(dout0_5) AT=1430.05n

.meas tran vdout0_6ck1420 FIND v(dout0_6) AT=1430.05n

.meas tran vdout0_7ck1420 FIND v(dout0_7) AT=1430.05n

.meas tran vdout0_8ck1420 FIND v(dout0_8) AT=1430.05n

.meas tran vdout0_9ck1420 FIND v(dout0_9) AT=1430.05n

.meas tran vdout0_10ck1420 FIND v(dout0_10) AT=1430.05n

.meas tran vdout0_11ck1420 FIND v(dout0_11) AT=1430.05n

.meas tran vdout0_12ck1420 FIND v(dout0_12) AT=1430.05n

.meas tran vdout0_13ck1420 FIND v(dout0_13) AT=1430.05n

.meas tran vdout0_14ck1420 FIND v(dout0_14) AT=1430.05n

.meas tran vdout0_15ck1420 FIND v(dout0_15) AT=1430.05n

.meas tran vdout0_16ck1420 FIND v(dout0_16) AT=1430.05n

.meas tran vdout0_17ck1420 FIND v(dout0_17) AT=1430.05n

.meas tran vdout0_18ck1420 FIND v(dout0_18) AT=1430.05n

.meas tran vdout0_19ck1420 FIND v(dout0_19) AT=1430.05n

.meas tran vdout0_20ck1420 FIND v(dout0_20) AT=1430.05n

.meas tran vdout0_21ck1420 FIND v(dout0_21) AT=1430.05n

.meas tran vdout0_22ck1420 FIND v(dout0_22) AT=1430.05n

.meas tran vdout0_23ck1420 FIND v(dout0_23) AT=1430.05n

.meas tran vdout0_24ck1420 FIND v(dout0_24) AT=1430.05n

.meas tran vdout0_25ck1420 FIND v(dout0_25) AT=1430.05n

.meas tran vdout0_26ck1420 FIND v(dout0_26) AT=1430.05n

.meas tran vdout0_27ck1420 FIND v(dout0_27) AT=1430.05n

.meas tran vdout0_28ck1420 FIND v(dout0_28) AT=1430.05n

.meas tran vdout0_29ck1420 FIND v(dout0_29) AT=1430.05n

.meas tran vdout0_30ck1420 FIND v(dout0_30) AT=1430.05n

.meas tran vdout0_31ck1420 FIND v(dout0_31) AT=1430.05n

.meas tran vdout0_32ck1420 FIND v(dout0_32) AT=1430.05n

.meas tran vdout0_0ck1430 FIND v(dout0_0) AT=1440.05n

.meas tran vdout0_1ck1430 FIND v(dout0_1) AT=1440.05n

.meas tran vdout0_2ck1430 FIND v(dout0_2) AT=1440.05n

.meas tran vdout0_3ck1430 FIND v(dout0_3) AT=1440.05n

.meas tran vdout0_4ck1430 FIND v(dout0_4) AT=1440.05n

.meas tran vdout0_5ck1430 FIND v(dout0_5) AT=1440.05n

.meas tran vdout0_6ck1430 FIND v(dout0_6) AT=1440.05n

.meas tran vdout0_7ck1430 FIND v(dout0_7) AT=1440.05n

.meas tran vdout0_8ck1430 FIND v(dout0_8) AT=1440.05n

.meas tran vdout0_9ck1430 FIND v(dout0_9) AT=1440.05n

.meas tran vdout0_10ck1430 FIND v(dout0_10) AT=1440.05n

.meas tran vdout0_11ck1430 FIND v(dout0_11) AT=1440.05n

.meas tran vdout0_12ck1430 FIND v(dout0_12) AT=1440.05n

.meas tran vdout0_13ck1430 FIND v(dout0_13) AT=1440.05n

.meas tran vdout0_14ck1430 FIND v(dout0_14) AT=1440.05n

.meas tran vdout0_15ck1430 FIND v(dout0_15) AT=1440.05n

.meas tran vdout0_16ck1430 FIND v(dout0_16) AT=1440.05n

.meas tran vdout0_17ck1430 FIND v(dout0_17) AT=1440.05n

.meas tran vdout0_18ck1430 FIND v(dout0_18) AT=1440.05n

.meas tran vdout0_19ck1430 FIND v(dout0_19) AT=1440.05n

.meas tran vdout0_20ck1430 FIND v(dout0_20) AT=1440.05n

.meas tran vdout0_21ck1430 FIND v(dout0_21) AT=1440.05n

.meas tran vdout0_22ck1430 FIND v(dout0_22) AT=1440.05n

.meas tran vdout0_23ck1430 FIND v(dout0_23) AT=1440.05n

.meas tran vdout0_24ck1430 FIND v(dout0_24) AT=1440.05n

.meas tran vdout0_25ck1430 FIND v(dout0_25) AT=1440.05n

.meas tran vdout0_26ck1430 FIND v(dout0_26) AT=1440.05n

.meas tran vdout0_27ck1430 FIND v(dout0_27) AT=1440.05n

.meas tran vdout0_28ck1430 FIND v(dout0_28) AT=1440.05n

.meas tran vdout0_29ck1430 FIND v(dout0_29) AT=1440.05n

.meas tran vdout0_30ck1430 FIND v(dout0_30) AT=1440.05n

.meas tran vdout0_31ck1430 FIND v(dout0_31) AT=1440.05n

.meas tran vdout0_32ck1430 FIND v(dout0_32) AT=1440.05n

.meas tran vdout0_0ck1440 FIND v(dout0_0) AT=1450.05n

.meas tran vdout0_1ck1440 FIND v(dout0_1) AT=1450.05n

.meas tran vdout0_2ck1440 FIND v(dout0_2) AT=1450.05n

.meas tran vdout0_3ck1440 FIND v(dout0_3) AT=1450.05n

.meas tran vdout0_4ck1440 FIND v(dout0_4) AT=1450.05n

.meas tran vdout0_5ck1440 FIND v(dout0_5) AT=1450.05n

.meas tran vdout0_6ck1440 FIND v(dout0_6) AT=1450.05n

.meas tran vdout0_7ck1440 FIND v(dout0_7) AT=1450.05n

.meas tran vdout0_8ck1440 FIND v(dout0_8) AT=1450.05n

.meas tran vdout0_9ck1440 FIND v(dout0_9) AT=1450.05n

.meas tran vdout0_10ck1440 FIND v(dout0_10) AT=1450.05n

.meas tran vdout0_11ck1440 FIND v(dout0_11) AT=1450.05n

.meas tran vdout0_12ck1440 FIND v(dout0_12) AT=1450.05n

.meas tran vdout0_13ck1440 FIND v(dout0_13) AT=1450.05n

.meas tran vdout0_14ck1440 FIND v(dout0_14) AT=1450.05n

.meas tran vdout0_15ck1440 FIND v(dout0_15) AT=1450.05n

.meas tran vdout0_16ck1440 FIND v(dout0_16) AT=1450.05n

.meas tran vdout0_17ck1440 FIND v(dout0_17) AT=1450.05n

.meas tran vdout0_18ck1440 FIND v(dout0_18) AT=1450.05n

.meas tran vdout0_19ck1440 FIND v(dout0_19) AT=1450.05n

.meas tran vdout0_20ck1440 FIND v(dout0_20) AT=1450.05n

.meas tran vdout0_21ck1440 FIND v(dout0_21) AT=1450.05n

.meas tran vdout0_22ck1440 FIND v(dout0_22) AT=1450.05n

.meas tran vdout0_23ck1440 FIND v(dout0_23) AT=1450.05n

.meas tran vdout0_24ck1440 FIND v(dout0_24) AT=1450.05n

.meas tran vdout0_25ck1440 FIND v(dout0_25) AT=1450.05n

.meas tran vdout0_26ck1440 FIND v(dout0_26) AT=1450.05n

.meas tran vdout0_27ck1440 FIND v(dout0_27) AT=1450.05n

.meas tran vdout0_28ck1440 FIND v(dout0_28) AT=1450.05n

.meas tran vdout0_29ck1440 FIND v(dout0_29) AT=1450.05n

.meas tran vdout0_30ck1440 FIND v(dout0_30) AT=1450.05n

.meas tran vdout0_31ck1440 FIND v(dout0_31) AT=1450.05n

.meas tran vdout0_32ck1440 FIND v(dout0_32) AT=1450.05n

.meas tran vdout0_0ck1460 FIND v(dout0_0) AT=1470.05n

.meas tran vdout0_1ck1460 FIND v(dout0_1) AT=1470.05n

.meas tran vdout0_2ck1460 FIND v(dout0_2) AT=1470.05n

.meas tran vdout0_3ck1460 FIND v(dout0_3) AT=1470.05n

.meas tran vdout0_4ck1460 FIND v(dout0_4) AT=1470.05n

.meas tran vdout0_5ck1460 FIND v(dout0_5) AT=1470.05n

.meas tran vdout0_6ck1460 FIND v(dout0_6) AT=1470.05n

.meas tran vdout0_7ck1460 FIND v(dout0_7) AT=1470.05n

.meas tran vdout0_8ck1460 FIND v(dout0_8) AT=1470.05n

.meas tran vdout0_9ck1460 FIND v(dout0_9) AT=1470.05n

.meas tran vdout0_10ck1460 FIND v(dout0_10) AT=1470.05n

.meas tran vdout0_11ck1460 FIND v(dout0_11) AT=1470.05n

.meas tran vdout0_12ck1460 FIND v(dout0_12) AT=1470.05n

.meas tran vdout0_13ck1460 FIND v(dout0_13) AT=1470.05n

.meas tran vdout0_14ck1460 FIND v(dout0_14) AT=1470.05n

.meas tran vdout0_15ck1460 FIND v(dout0_15) AT=1470.05n

.meas tran vdout0_16ck1460 FIND v(dout0_16) AT=1470.05n

.meas tran vdout0_17ck1460 FIND v(dout0_17) AT=1470.05n

.meas tran vdout0_18ck1460 FIND v(dout0_18) AT=1470.05n

.meas tran vdout0_19ck1460 FIND v(dout0_19) AT=1470.05n

.meas tran vdout0_20ck1460 FIND v(dout0_20) AT=1470.05n

.meas tran vdout0_21ck1460 FIND v(dout0_21) AT=1470.05n

.meas tran vdout0_22ck1460 FIND v(dout0_22) AT=1470.05n

.meas tran vdout0_23ck1460 FIND v(dout0_23) AT=1470.05n

.meas tran vdout0_24ck1460 FIND v(dout0_24) AT=1470.05n

.meas tran vdout0_25ck1460 FIND v(dout0_25) AT=1470.05n

.meas tran vdout0_26ck1460 FIND v(dout0_26) AT=1470.05n

.meas tran vdout0_27ck1460 FIND v(dout0_27) AT=1470.05n

.meas tran vdout0_28ck1460 FIND v(dout0_28) AT=1470.05n

.meas tran vdout0_29ck1460 FIND v(dout0_29) AT=1470.05n

.meas tran vdout0_30ck1460 FIND v(dout0_30) AT=1470.05n

.meas tran vdout0_31ck1460 FIND v(dout0_31) AT=1470.05n

.meas tran vdout0_32ck1460 FIND v(dout0_32) AT=1470.05n

.meas tran vdout0_0ck1510 FIND v(dout0_0) AT=1520.05n

.meas tran vdout0_1ck1510 FIND v(dout0_1) AT=1520.05n

.meas tran vdout0_2ck1510 FIND v(dout0_2) AT=1520.05n

.meas tran vdout0_3ck1510 FIND v(dout0_3) AT=1520.05n

.meas tran vdout0_4ck1510 FIND v(dout0_4) AT=1520.05n

.meas tran vdout0_5ck1510 FIND v(dout0_5) AT=1520.05n

.meas tran vdout0_6ck1510 FIND v(dout0_6) AT=1520.05n

.meas tran vdout0_7ck1510 FIND v(dout0_7) AT=1520.05n

.meas tran vdout0_8ck1510 FIND v(dout0_8) AT=1520.05n

.meas tran vdout0_9ck1510 FIND v(dout0_9) AT=1520.05n

.meas tran vdout0_10ck1510 FIND v(dout0_10) AT=1520.05n

.meas tran vdout0_11ck1510 FIND v(dout0_11) AT=1520.05n

.meas tran vdout0_12ck1510 FIND v(dout0_12) AT=1520.05n

.meas tran vdout0_13ck1510 FIND v(dout0_13) AT=1520.05n

.meas tran vdout0_14ck1510 FIND v(dout0_14) AT=1520.05n

.meas tran vdout0_15ck1510 FIND v(dout0_15) AT=1520.05n

.meas tran vdout0_16ck1510 FIND v(dout0_16) AT=1520.05n

.meas tran vdout0_17ck1510 FIND v(dout0_17) AT=1520.05n

.meas tran vdout0_18ck1510 FIND v(dout0_18) AT=1520.05n

.meas tran vdout0_19ck1510 FIND v(dout0_19) AT=1520.05n

.meas tran vdout0_20ck1510 FIND v(dout0_20) AT=1520.05n

.meas tran vdout0_21ck1510 FIND v(dout0_21) AT=1520.05n

.meas tran vdout0_22ck1510 FIND v(dout0_22) AT=1520.05n

.meas tran vdout0_23ck1510 FIND v(dout0_23) AT=1520.05n

.meas tran vdout0_24ck1510 FIND v(dout0_24) AT=1520.05n

.meas tran vdout0_25ck1510 FIND v(dout0_25) AT=1520.05n

.meas tran vdout0_26ck1510 FIND v(dout0_26) AT=1520.05n

.meas tran vdout0_27ck1510 FIND v(dout0_27) AT=1520.05n

.meas tran vdout0_28ck1510 FIND v(dout0_28) AT=1520.05n

.meas tran vdout0_29ck1510 FIND v(dout0_29) AT=1520.05n

.meas tran vdout0_30ck1510 FIND v(dout0_30) AT=1520.05n

.meas tran vdout0_31ck1510 FIND v(dout0_31) AT=1520.05n

.meas tran vdout0_32ck1510 FIND v(dout0_32) AT=1520.05n

.meas tran vdout0_0ck1540 FIND v(dout0_0) AT=1550.05n

.meas tran vdout0_1ck1540 FIND v(dout0_1) AT=1550.05n

.meas tran vdout0_2ck1540 FIND v(dout0_2) AT=1550.05n

.meas tran vdout0_3ck1540 FIND v(dout0_3) AT=1550.05n

.meas tran vdout0_4ck1540 FIND v(dout0_4) AT=1550.05n

.meas tran vdout0_5ck1540 FIND v(dout0_5) AT=1550.05n

.meas tran vdout0_6ck1540 FIND v(dout0_6) AT=1550.05n

.meas tran vdout0_7ck1540 FIND v(dout0_7) AT=1550.05n

.meas tran vdout0_8ck1540 FIND v(dout0_8) AT=1550.05n

.meas tran vdout0_9ck1540 FIND v(dout0_9) AT=1550.05n

.meas tran vdout0_10ck1540 FIND v(dout0_10) AT=1550.05n

.meas tran vdout0_11ck1540 FIND v(dout0_11) AT=1550.05n

.meas tran vdout0_12ck1540 FIND v(dout0_12) AT=1550.05n

.meas tran vdout0_13ck1540 FIND v(dout0_13) AT=1550.05n

.meas tran vdout0_14ck1540 FIND v(dout0_14) AT=1550.05n

.meas tran vdout0_15ck1540 FIND v(dout0_15) AT=1550.05n

.meas tran vdout0_16ck1540 FIND v(dout0_16) AT=1550.05n

.meas tran vdout0_17ck1540 FIND v(dout0_17) AT=1550.05n

.meas tran vdout0_18ck1540 FIND v(dout0_18) AT=1550.05n

.meas tran vdout0_19ck1540 FIND v(dout0_19) AT=1550.05n

.meas tran vdout0_20ck1540 FIND v(dout0_20) AT=1550.05n

.meas tran vdout0_21ck1540 FIND v(dout0_21) AT=1550.05n

.meas tran vdout0_22ck1540 FIND v(dout0_22) AT=1550.05n

.meas tran vdout0_23ck1540 FIND v(dout0_23) AT=1550.05n

.meas tran vdout0_24ck1540 FIND v(dout0_24) AT=1550.05n

.meas tran vdout0_25ck1540 FIND v(dout0_25) AT=1550.05n

.meas tran vdout0_26ck1540 FIND v(dout0_26) AT=1550.05n

.meas tran vdout0_27ck1540 FIND v(dout0_27) AT=1550.05n

.meas tran vdout0_28ck1540 FIND v(dout0_28) AT=1550.05n

.meas tran vdout0_29ck1540 FIND v(dout0_29) AT=1550.05n

.meas tran vdout0_30ck1540 FIND v(dout0_30) AT=1550.05n

.meas tran vdout0_31ck1540 FIND v(dout0_31) AT=1550.05n

.meas tran vdout0_32ck1540 FIND v(dout0_32) AT=1550.05n

.meas tran vdout0_0ck1550 FIND v(dout0_0) AT=1560.05n

.meas tran vdout0_1ck1550 FIND v(dout0_1) AT=1560.05n

.meas tran vdout0_2ck1550 FIND v(dout0_2) AT=1560.05n

.meas tran vdout0_3ck1550 FIND v(dout0_3) AT=1560.05n

.meas tran vdout0_4ck1550 FIND v(dout0_4) AT=1560.05n

.meas tran vdout0_5ck1550 FIND v(dout0_5) AT=1560.05n

.meas tran vdout0_6ck1550 FIND v(dout0_6) AT=1560.05n

.meas tran vdout0_7ck1550 FIND v(dout0_7) AT=1560.05n

.meas tran vdout0_8ck1550 FIND v(dout0_8) AT=1560.05n

.meas tran vdout0_9ck1550 FIND v(dout0_9) AT=1560.05n

.meas tran vdout0_10ck1550 FIND v(dout0_10) AT=1560.05n

.meas tran vdout0_11ck1550 FIND v(dout0_11) AT=1560.05n

.meas tran vdout0_12ck1550 FIND v(dout0_12) AT=1560.05n

.meas tran vdout0_13ck1550 FIND v(dout0_13) AT=1560.05n

.meas tran vdout0_14ck1550 FIND v(dout0_14) AT=1560.05n

.meas tran vdout0_15ck1550 FIND v(dout0_15) AT=1560.05n

.meas tran vdout0_16ck1550 FIND v(dout0_16) AT=1560.05n

.meas tran vdout0_17ck1550 FIND v(dout0_17) AT=1560.05n

.meas tran vdout0_18ck1550 FIND v(dout0_18) AT=1560.05n

.meas tran vdout0_19ck1550 FIND v(dout0_19) AT=1560.05n

.meas tran vdout0_20ck1550 FIND v(dout0_20) AT=1560.05n

.meas tran vdout0_21ck1550 FIND v(dout0_21) AT=1560.05n

.meas tran vdout0_22ck1550 FIND v(dout0_22) AT=1560.05n

.meas tran vdout0_23ck1550 FIND v(dout0_23) AT=1560.05n

.meas tran vdout0_24ck1550 FIND v(dout0_24) AT=1560.05n

.meas tran vdout0_25ck1550 FIND v(dout0_25) AT=1560.05n

.meas tran vdout0_26ck1550 FIND v(dout0_26) AT=1560.05n

.meas tran vdout0_27ck1550 FIND v(dout0_27) AT=1560.05n

.meas tran vdout0_28ck1550 FIND v(dout0_28) AT=1560.05n

.meas tran vdout0_29ck1550 FIND v(dout0_29) AT=1560.05n

.meas tran vdout0_30ck1550 FIND v(dout0_30) AT=1560.05n

.meas tran vdout0_31ck1550 FIND v(dout0_31) AT=1560.05n

.meas tran vdout0_32ck1550 FIND v(dout0_32) AT=1560.05n

.meas tran vdout0_0ck1560 FIND v(dout0_0) AT=1570.05n

.meas tran vdout0_1ck1560 FIND v(dout0_1) AT=1570.05n

.meas tran vdout0_2ck1560 FIND v(dout0_2) AT=1570.05n

.meas tran vdout0_3ck1560 FIND v(dout0_3) AT=1570.05n

.meas tran vdout0_4ck1560 FIND v(dout0_4) AT=1570.05n

.meas tran vdout0_5ck1560 FIND v(dout0_5) AT=1570.05n

.meas tran vdout0_6ck1560 FIND v(dout0_6) AT=1570.05n

.meas tran vdout0_7ck1560 FIND v(dout0_7) AT=1570.05n

.meas tran vdout0_8ck1560 FIND v(dout0_8) AT=1570.05n

.meas tran vdout0_9ck1560 FIND v(dout0_9) AT=1570.05n

.meas tran vdout0_10ck1560 FIND v(dout0_10) AT=1570.05n

.meas tran vdout0_11ck1560 FIND v(dout0_11) AT=1570.05n

.meas tran vdout0_12ck1560 FIND v(dout0_12) AT=1570.05n

.meas tran vdout0_13ck1560 FIND v(dout0_13) AT=1570.05n

.meas tran vdout0_14ck1560 FIND v(dout0_14) AT=1570.05n

.meas tran vdout0_15ck1560 FIND v(dout0_15) AT=1570.05n

.meas tran vdout0_16ck1560 FIND v(dout0_16) AT=1570.05n

.meas tran vdout0_17ck1560 FIND v(dout0_17) AT=1570.05n

.meas tran vdout0_18ck1560 FIND v(dout0_18) AT=1570.05n

.meas tran vdout0_19ck1560 FIND v(dout0_19) AT=1570.05n

.meas tran vdout0_20ck1560 FIND v(dout0_20) AT=1570.05n

.meas tran vdout0_21ck1560 FIND v(dout0_21) AT=1570.05n

.meas tran vdout0_22ck1560 FIND v(dout0_22) AT=1570.05n

.meas tran vdout0_23ck1560 FIND v(dout0_23) AT=1570.05n

.meas tran vdout0_24ck1560 FIND v(dout0_24) AT=1570.05n

.meas tran vdout0_25ck1560 FIND v(dout0_25) AT=1570.05n

.meas tran vdout0_26ck1560 FIND v(dout0_26) AT=1570.05n

.meas tran vdout0_27ck1560 FIND v(dout0_27) AT=1570.05n

.meas tran vdout0_28ck1560 FIND v(dout0_28) AT=1570.05n

.meas tran vdout0_29ck1560 FIND v(dout0_29) AT=1570.05n

.meas tran vdout0_30ck1560 FIND v(dout0_30) AT=1570.05n

.meas tran vdout0_31ck1560 FIND v(dout0_31) AT=1570.05n

.meas tran vdout0_32ck1560 FIND v(dout0_32) AT=1570.05n

.meas tran vdout0_0ck1570 FIND v(dout0_0) AT=1580.05n

.meas tran vdout0_1ck1570 FIND v(dout0_1) AT=1580.05n

.meas tran vdout0_2ck1570 FIND v(dout0_2) AT=1580.05n

.meas tran vdout0_3ck1570 FIND v(dout0_3) AT=1580.05n

.meas tran vdout0_4ck1570 FIND v(dout0_4) AT=1580.05n

.meas tran vdout0_5ck1570 FIND v(dout0_5) AT=1580.05n

.meas tran vdout0_6ck1570 FIND v(dout0_6) AT=1580.05n

.meas tran vdout0_7ck1570 FIND v(dout0_7) AT=1580.05n

.meas tran vdout0_8ck1570 FIND v(dout0_8) AT=1580.05n

.meas tran vdout0_9ck1570 FIND v(dout0_9) AT=1580.05n

.meas tran vdout0_10ck1570 FIND v(dout0_10) AT=1580.05n

.meas tran vdout0_11ck1570 FIND v(dout0_11) AT=1580.05n

.meas tran vdout0_12ck1570 FIND v(dout0_12) AT=1580.05n

.meas tran vdout0_13ck1570 FIND v(dout0_13) AT=1580.05n

.meas tran vdout0_14ck1570 FIND v(dout0_14) AT=1580.05n

.meas tran vdout0_15ck1570 FIND v(dout0_15) AT=1580.05n

.meas tran vdout0_16ck1570 FIND v(dout0_16) AT=1580.05n

.meas tran vdout0_17ck1570 FIND v(dout0_17) AT=1580.05n

.meas tran vdout0_18ck1570 FIND v(dout0_18) AT=1580.05n

.meas tran vdout0_19ck1570 FIND v(dout0_19) AT=1580.05n

.meas tran vdout0_20ck1570 FIND v(dout0_20) AT=1580.05n

.meas tran vdout0_21ck1570 FIND v(dout0_21) AT=1580.05n

.meas tran vdout0_22ck1570 FIND v(dout0_22) AT=1580.05n

.meas tran vdout0_23ck1570 FIND v(dout0_23) AT=1580.05n

.meas tran vdout0_24ck1570 FIND v(dout0_24) AT=1580.05n

.meas tran vdout0_25ck1570 FIND v(dout0_25) AT=1580.05n

.meas tran vdout0_26ck1570 FIND v(dout0_26) AT=1580.05n

.meas tran vdout0_27ck1570 FIND v(dout0_27) AT=1580.05n

.meas tran vdout0_28ck1570 FIND v(dout0_28) AT=1580.05n

.meas tran vdout0_29ck1570 FIND v(dout0_29) AT=1580.05n

.meas tran vdout0_30ck1570 FIND v(dout0_30) AT=1580.05n

.meas tran vdout0_31ck1570 FIND v(dout0_31) AT=1580.05n

.meas tran vdout0_32ck1570 FIND v(dout0_32) AT=1580.05n

.meas tran vdout0_0ck1600 FIND v(dout0_0) AT=1610.05n

.meas tran vdout0_1ck1600 FIND v(dout0_1) AT=1610.05n

.meas tran vdout0_2ck1600 FIND v(dout0_2) AT=1610.05n

.meas tran vdout0_3ck1600 FIND v(dout0_3) AT=1610.05n

.meas tran vdout0_4ck1600 FIND v(dout0_4) AT=1610.05n

.meas tran vdout0_5ck1600 FIND v(dout0_5) AT=1610.05n

.meas tran vdout0_6ck1600 FIND v(dout0_6) AT=1610.05n

.meas tran vdout0_7ck1600 FIND v(dout0_7) AT=1610.05n

.meas tran vdout0_8ck1600 FIND v(dout0_8) AT=1610.05n

.meas tran vdout0_9ck1600 FIND v(dout0_9) AT=1610.05n

.meas tran vdout0_10ck1600 FIND v(dout0_10) AT=1610.05n

.meas tran vdout0_11ck1600 FIND v(dout0_11) AT=1610.05n

.meas tran vdout0_12ck1600 FIND v(dout0_12) AT=1610.05n

.meas tran vdout0_13ck1600 FIND v(dout0_13) AT=1610.05n

.meas tran vdout0_14ck1600 FIND v(dout0_14) AT=1610.05n

.meas tran vdout0_15ck1600 FIND v(dout0_15) AT=1610.05n

.meas tran vdout0_16ck1600 FIND v(dout0_16) AT=1610.05n

.meas tran vdout0_17ck1600 FIND v(dout0_17) AT=1610.05n

.meas tran vdout0_18ck1600 FIND v(dout0_18) AT=1610.05n

.meas tran vdout0_19ck1600 FIND v(dout0_19) AT=1610.05n

.meas tran vdout0_20ck1600 FIND v(dout0_20) AT=1610.05n

.meas tran vdout0_21ck1600 FIND v(dout0_21) AT=1610.05n

.meas tran vdout0_22ck1600 FIND v(dout0_22) AT=1610.05n

.meas tran vdout0_23ck1600 FIND v(dout0_23) AT=1610.05n

.meas tran vdout0_24ck1600 FIND v(dout0_24) AT=1610.05n

.meas tran vdout0_25ck1600 FIND v(dout0_25) AT=1610.05n

.meas tran vdout0_26ck1600 FIND v(dout0_26) AT=1610.05n

.meas tran vdout0_27ck1600 FIND v(dout0_27) AT=1610.05n

.meas tran vdout0_28ck1600 FIND v(dout0_28) AT=1610.05n

.meas tran vdout0_29ck1600 FIND v(dout0_29) AT=1610.05n

.meas tran vdout0_30ck1600 FIND v(dout0_30) AT=1610.05n

.meas tran vdout0_31ck1600 FIND v(dout0_31) AT=1610.05n

.meas tran vdout0_32ck1600 FIND v(dout0_32) AT=1610.05n

.meas tran vdout0_0ck1610 FIND v(dout0_0) AT=1620.05n

.meas tran vdout0_1ck1610 FIND v(dout0_1) AT=1620.05n

.meas tran vdout0_2ck1610 FIND v(dout0_2) AT=1620.05n

.meas tran vdout0_3ck1610 FIND v(dout0_3) AT=1620.05n

.meas tran vdout0_4ck1610 FIND v(dout0_4) AT=1620.05n

.meas tran vdout0_5ck1610 FIND v(dout0_5) AT=1620.05n

.meas tran vdout0_6ck1610 FIND v(dout0_6) AT=1620.05n

.meas tran vdout0_7ck1610 FIND v(dout0_7) AT=1620.05n

.meas tran vdout0_8ck1610 FIND v(dout0_8) AT=1620.05n

.meas tran vdout0_9ck1610 FIND v(dout0_9) AT=1620.05n

.meas tran vdout0_10ck1610 FIND v(dout0_10) AT=1620.05n

.meas tran vdout0_11ck1610 FIND v(dout0_11) AT=1620.05n

.meas tran vdout0_12ck1610 FIND v(dout0_12) AT=1620.05n

.meas tran vdout0_13ck1610 FIND v(dout0_13) AT=1620.05n

.meas tran vdout0_14ck1610 FIND v(dout0_14) AT=1620.05n

.meas tran vdout0_15ck1610 FIND v(dout0_15) AT=1620.05n

.meas tran vdout0_16ck1610 FIND v(dout0_16) AT=1620.05n

.meas tran vdout0_17ck1610 FIND v(dout0_17) AT=1620.05n

.meas tran vdout0_18ck1610 FIND v(dout0_18) AT=1620.05n

.meas tran vdout0_19ck1610 FIND v(dout0_19) AT=1620.05n

.meas tran vdout0_20ck1610 FIND v(dout0_20) AT=1620.05n

.meas tran vdout0_21ck1610 FIND v(dout0_21) AT=1620.05n

.meas tran vdout0_22ck1610 FIND v(dout0_22) AT=1620.05n

.meas tran vdout0_23ck1610 FIND v(dout0_23) AT=1620.05n

.meas tran vdout0_24ck1610 FIND v(dout0_24) AT=1620.05n

.meas tran vdout0_25ck1610 FIND v(dout0_25) AT=1620.05n

.meas tran vdout0_26ck1610 FIND v(dout0_26) AT=1620.05n

.meas tran vdout0_27ck1610 FIND v(dout0_27) AT=1620.05n

.meas tran vdout0_28ck1610 FIND v(dout0_28) AT=1620.05n

.meas tran vdout0_29ck1610 FIND v(dout0_29) AT=1620.05n

.meas tran vdout0_30ck1610 FIND v(dout0_30) AT=1620.05n

.meas tran vdout0_31ck1610 FIND v(dout0_31) AT=1620.05n

.meas tran vdout0_32ck1610 FIND v(dout0_32) AT=1620.05n

.meas tran vdout0_0ck1620 FIND v(dout0_0) AT=1630.05n

.meas tran vdout0_1ck1620 FIND v(dout0_1) AT=1630.05n

.meas tran vdout0_2ck1620 FIND v(dout0_2) AT=1630.05n

.meas tran vdout0_3ck1620 FIND v(dout0_3) AT=1630.05n

.meas tran vdout0_4ck1620 FIND v(dout0_4) AT=1630.05n

.meas tran vdout0_5ck1620 FIND v(dout0_5) AT=1630.05n

.meas tran vdout0_6ck1620 FIND v(dout0_6) AT=1630.05n

.meas tran vdout0_7ck1620 FIND v(dout0_7) AT=1630.05n

.meas tran vdout0_8ck1620 FIND v(dout0_8) AT=1630.05n

.meas tran vdout0_9ck1620 FIND v(dout0_9) AT=1630.05n

.meas tran vdout0_10ck1620 FIND v(dout0_10) AT=1630.05n

.meas tran vdout0_11ck1620 FIND v(dout0_11) AT=1630.05n

.meas tran vdout0_12ck1620 FIND v(dout0_12) AT=1630.05n

.meas tran vdout0_13ck1620 FIND v(dout0_13) AT=1630.05n

.meas tran vdout0_14ck1620 FIND v(dout0_14) AT=1630.05n

.meas tran vdout0_15ck1620 FIND v(dout0_15) AT=1630.05n

.meas tran vdout0_16ck1620 FIND v(dout0_16) AT=1630.05n

.meas tran vdout0_17ck1620 FIND v(dout0_17) AT=1630.05n

.meas tran vdout0_18ck1620 FIND v(dout0_18) AT=1630.05n

.meas tran vdout0_19ck1620 FIND v(dout0_19) AT=1630.05n

.meas tran vdout0_20ck1620 FIND v(dout0_20) AT=1630.05n

.meas tran vdout0_21ck1620 FIND v(dout0_21) AT=1630.05n

.meas tran vdout0_22ck1620 FIND v(dout0_22) AT=1630.05n

.meas tran vdout0_23ck1620 FIND v(dout0_23) AT=1630.05n

.meas tran vdout0_24ck1620 FIND v(dout0_24) AT=1630.05n

.meas tran vdout0_25ck1620 FIND v(dout0_25) AT=1630.05n

.meas tran vdout0_26ck1620 FIND v(dout0_26) AT=1630.05n

.meas tran vdout0_27ck1620 FIND v(dout0_27) AT=1630.05n

.meas tran vdout0_28ck1620 FIND v(dout0_28) AT=1630.05n

.meas tran vdout0_29ck1620 FIND v(dout0_29) AT=1630.05n

.meas tran vdout0_30ck1620 FIND v(dout0_30) AT=1630.05n

.meas tran vdout0_31ck1620 FIND v(dout0_31) AT=1630.05n

.meas tran vdout0_32ck1620 FIND v(dout0_32) AT=1630.05n

.meas tran vdout0_0ck1630 FIND v(dout0_0) AT=1640.05n

.meas tran vdout0_1ck1630 FIND v(dout0_1) AT=1640.05n

.meas tran vdout0_2ck1630 FIND v(dout0_2) AT=1640.05n

.meas tran vdout0_3ck1630 FIND v(dout0_3) AT=1640.05n

.meas tran vdout0_4ck1630 FIND v(dout0_4) AT=1640.05n

.meas tran vdout0_5ck1630 FIND v(dout0_5) AT=1640.05n

.meas tran vdout0_6ck1630 FIND v(dout0_6) AT=1640.05n

.meas tran vdout0_7ck1630 FIND v(dout0_7) AT=1640.05n

.meas tran vdout0_8ck1630 FIND v(dout0_8) AT=1640.05n

.meas tran vdout0_9ck1630 FIND v(dout0_9) AT=1640.05n

.meas tran vdout0_10ck1630 FIND v(dout0_10) AT=1640.05n

.meas tran vdout0_11ck1630 FIND v(dout0_11) AT=1640.05n

.meas tran vdout0_12ck1630 FIND v(dout0_12) AT=1640.05n

.meas tran vdout0_13ck1630 FIND v(dout0_13) AT=1640.05n

.meas tran vdout0_14ck1630 FIND v(dout0_14) AT=1640.05n

.meas tran vdout0_15ck1630 FIND v(dout0_15) AT=1640.05n

.meas tran vdout0_16ck1630 FIND v(dout0_16) AT=1640.05n

.meas tran vdout0_17ck1630 FIND v(dout0_17) AT=1640.05n

.meas tran vdout0_18ck1630 FIND v(dout0_18) AT=1640.05n

.meas tran vdout0_19ck1630 FIND v(dout0_19) AT=1640.05n

.meas tran vdout0_20ck1630 FIND v(dout0_20) AT=1640.05n

.meas tran vdout0_21ck1630 FIND v(dout0_21) AT=1640.05n

.meas tran vdout0_22ck1630 FIND v(dout0_22) AT=1640.05n

.meas tran vdout0_23ck1630 FIND v(dout0_23) AT=1640.05n

.meas tran vdout0_24ck1630 FIND v(dout0_24) AT=1640.05n

.meas tran vdout0_25ck1630 FIND v(dout0_25) AT=1640.05n

.meas tran vdout0_26ck1630 FIND v(dout0_26) AT=1640.05n

.meas tran vdout0_27ck1630 FIND v(dout0_27) AT=1640.05n

.meas tran vdout0_28ck1630 FIND v(dout0_28) AT=1640.05n

.meas tran vdout0_29ck1630 FIND v(dout0_29) AT=1640.05n

.meas tran vdout0_30ck1630 FIND v(dout0_30) AT=1640.05n

.meas tran vdout0_31ck1630 FIND v(dout0_31) AT=1640.05n

.meas tran vdout0_32ck1630 FIND v(dout0_32) AT=1640.05n

.meas tran vdout0_0ck1670 FIND v(dout0_0) AT=1680.05n

.meas tran vdout0_1ck1670 FIND v(dout0_1) AT=1680.05n

.meas tran vdout0_2ck1670 FIND v(dout0_2) AT=1680.05n

.meas tran vdout0_3ck1670 FIND v(dout0_3) AT=1680.05n

.meas tran vdout0_4ck1670 FIND v(dout0_4) AT=1680.05n

.meas tran vdout0_5ck1670 FIND v(dout0_5) AT=1680.05n

.meas tran vdout0_6ck1670 FIND v(dout0_6) AT=1680.05n

.meas tran vdout0_7ck1670 FIND v(dout0_7) AT=1680.05n

.meas tran vdout0_8ck1670 FIND v(dout0_8) AT=1680.05n

.meas tran vdout0_9ck1670 FIND v(dout0_9) AT=1680.05n

.meas tran vdout0_10ck1670 FIND v(dout0_10) AT=1680.05n

.meas tran vdout0_11ck1670 FIND v(dout0_11) AT=1680.05n

.meas tran vdout0_12ck1670 FIND v(dout0_12) AT=1680.05n

.meas tran vdout0_13ck1670 FIND v(dout0_13) AT=1680.05n

.meas tran vdout0_14ck1670 FIND v(dout0_14) AT=1680.05n

.meas tran vdout0_15ck1670 FIND v(dout0_15) AT=1680.05n

.meas tran vdout0_16ck1670 FIND v(dout0_16) AT=1680.05n

.meas tran vdout0_17ck1670 FIND v(dout0_17) AT=1680.05n

.meas tran vdout0_18ck1670 FIND v(dout0_18) AT=1680.05n

.meas tran vdout0_19ck1670 FIND v(dout0_19) AT=1680.05n

.meas tran vdout0_20ck1670 FIND v(dout0_20) AT=1680.05n

.meas tran vdout0_21ck1670 FIND v(dout0_21) AT=1680.05n

.meas tran vdout0_22ck1670 FIND v(dout0_22) AT=1680.05n

.meas tran vdout0_23ck1670 FIND v(dout0_23) AT=1680.05n

.meas tran vdout0_24ck1670 FIND v(dout0_24) AT=1680.05n

.meas tran vdout0_25ck1670 FIND v(dout0_25) AT=1680.05n

.meas tran vdout0_26ck1670 FIND v(dout0_26) AT=1680.05n

.meas tran vdout0_27ck1670 FIND v(dout0_27) AT=1680.05n

.meas tran vdout0_28ck1670 FIND v(dout0_28) AT=1680.05n

.meas tran vdout0_29ck1670 FIND v(dout0_29) AT=1680.05n

.meas tran vdout0_30ck1670 FIND v(dout0_30) AT=1680.05n

.meas tran vdout0_31ck1670 FIND v(dout0_31) AT=1680.05n

.meas tran vdout0_32ck1670 FIND v(dout0_32) AT=1680.05n

.meas tran vdout0_0ck1680 FIND v(dout0_0) AT=1690.05n

.meas tran vdout0_1ck1680 FIND v(dout0_1) AT=1690.05n

.meas tran vdout0_2ck1680 FIND v(dout0_2) AT=1690.05n

.meas tran vdout0_3ck1680 FIND v(dout0_3) AT=1690.05n

.meas tran vdout0_4ck1680 FIND v(dout0_4) AT=1690.05n

.meas tran vdout0_5ck1680 FIND v(dout0_5) AT=1690.05n

.meas tran vdout0_6ck1680 FIND v(dout0_6) AT=1690.05n

.meas tran vdout0_7ck1680 FIND v(dout0_7) AT=1690.05n

.meas tran vdout0_8ck1680 FIND v(dout0_8) AT=1690.05n

.meas tran vdout0_9ck1680 FIND v(dout0_9) AT=1690.05n

.meas tran vdout0_10ck1680 FIND v(dout0_10) AT=1690.05n

.meas tran vdout0_11ck1680 FIND v(dout0_11) AT=1690.05n

.meas tran vdout0_12ck1680 FIND v(dout0_12) AT=1690.05n

.meas tran vdout0_13ck1680 FIND v(dout0_13) AT=1690.05n

.meas tran vdout0_14ck1680 FIND v(dout0_14) AT=1690.05n

.meas tran vdout0_15ck1680 FIND v(dout0_15) AT=1690.05n

.meas tran vdout0_16ck1680 FIND v(dout0_16) AT=1690.05n

.meas tran vdout0_17ck1680 FIND v(dout0_17) AT=1690.05n

.meas tran vdout0_18ck1680 FIND v(dout0_18) AT=1690.05n

.meas tran vdout0_19ck1680 FIND v(dout0_19) AT=1690.05n

.meas tran vdout0_20ck1680 FIND v(dout0_20) AT=1690.05n

.meas tran vdout0_21ck1680 FIND v(dout0_21) AT=1690.05n

.meas tran vdout0_22ck1680 FIND v(dout0_22) AT=1690.05n

.meas tran vdout0_23ck1680 FIND v(dout0_23) AT=1690.05n

.meas tran vdout0_24ck1680 FIND v(dout0_24) AT=1690.05n

.meas tran vdout0_25ck1680 FIND v(dout0_25) AT=1690.05n

.meas tran vdout0_26ck1680 FIND v(dout0_26) AT=1690.05n

.meas tran vdout0_27ck1680 FIND v(dout0_27) AT=1690.05n

.meas tran vdout0_28ck1680 FIND v(dout0_28) AT=1690.05n

.meas tran vdout0_29ck1680 FIND v(dout0_29) AT=1690.05n

.meas tran vdout0_30ck1680 FIND v(dout0_30) AT=1690.05n

.meas tran vdout0_31ck1680 FIND v(dout0_31) AT=1690.05n

.meas tran vdout0_32ck1680 FIND v(dout0_32) AT=1690.05n

.meas tran vdout0_0ck1690 FIND v(dout0_0) AT=1700.05n

.meas tran vdout0_1ck1690 FIND v(dout0_1) AT=1700.05n

.meas tran vdout0_2ck1690 FIND v(dout0_2) AT=1700.05n

.meas tran vdout0_3ck1690 FIND v(dout0_3) AT=1700.05n

.meas tran vdout0_4ck1690 FIND v(dout0_4) AT=1700.05n

.meas tran vdout0_5ck1690 FIND v(dout0_5) AT=1700.05n

.meas tran vdout0_6ck1690 FIND v(dout0_6) AT=1700.05n

.meas tran vdout0_7ck1690 FIND v(dout0_7) AT=1700.05n

.meas tran vdout0_8ck1690 FIND v(dout0_8) AT=1700.05n

.meas tran vdout0_9ck1690 FIND v(dout0_9) AT=1700.05n

.meas tran vdout0_10ck1690 FIND v(dout0_10) AT=1700.05n

.meas tran vdout0_11ck1690 FIND v(dout0_11) AT=1700.05n

.meas tran vdout0_12ck1690 FIND v(dout0_12) AT=1700.05n

.meas tran vdout0_13ck1690 FIND v(dout0_13) AT=1700.05n

.meas tran vdout0_14ck1690 FIND v(dout0_14) AT=1700.05n

.meas tran vdout0_15ck1690 FIND v(dout0_15) AT=1700.05n

.meas tran vdout0_16ck1690 FIND v(dout0_16) AT=1700.05n

.meas tran vdout0_17ck1690 FIND v(dout0_17) AT=1700.05n

.meas tran vdout0_18ck1690 FIND v(dout0_18) AT=1700.05n

.meas tran vdout0_19ck1690 FIND v(dout0_19) AT=1700.05n

.meas tran vdout0_20ck1690 FIND v(dout0_20) AT=1700.05n

.meas tran vdout0_21ck1690 FIND v(dout0_21) AT=1700.05n

.meas tran vdout0_22ck1690 FIND v(dout0_22) AT=1700.05n

.meas tran vdout0_23ck1690 FIND v(dout0_23) AT=1700.05n

.meas tran vdout0_24ck1690 FIND v(dout0_24) AT=1700.05n

.meas tran vdout0_25ck1690 FIND v(dout0_25) AT=1700.05n

.meas tran vdout0_26ck1690 FIND v(dout0_26) AT=1700.05n

.meas tran vdout0_27ck1690 FIND v(dout0_27) AT=1700.05n

.meas tran vdout0_28ck1690 FIND v(dout0_28) AT=1700.05n

.meas tran vdout0_29ck1690 FIND v(dout0_29) AT=1700.05n

.meas tran vdout0_30ck1690 FIND v(dout0_30) AT=1700.05n

.meas tran vdout0_31ck1690 FIND v(dout0_31) AT=1700.05n

.meas tran vdout0_32ck1690 FIND v(dout0_32) AT=1700.05n

.meas tran vdout0_0ck1780 FIND v(dout0_0) AT=1790.05n

.meas tran vdout0_1ck1780 FIND v(dout0_1) AT=1790.05n

.meas tran vdout0_2ck1780 FIND v(dout0_2) AT=1790.05n

.meas tran vdout0_3ck1780 FIND v(dout0_3) AT=1790.05n

.meas tran vdout0_4ck1780 FIND v(dout0_4) AT=1790.05n

.meas tran vdout0_5ck1780 FIND v(dout0_5) AT=1790.05n

.meas tran vdout0_6ck1780 FIND v(dout0_6) AT=1790.05n

.meas tran vdout0_7ck1780 FIND v(dout0_7) AT=1790.05n

.meas tran vdout0_8ck1780 FIND v(dout0_8) AT=1790.05n

.meas tran vdout0_9ck1780 FIND v(dout0_9) AT=1790.05n

.meas tran vdout0_10ck1780 FIND v(dout0_10) AT=1790.05n

.meas tran vdout0_11ck1780 FIND v(dout0_11) AT=1790.05n

.meas tran vdout0_12ck1780 FIND v(dout0_12) AT=1790.05n

.meas tran vdout0_13ck1780 FIND v(dout0_13) AT=1790.05n

.meas tran vdout0_14ck1780 FIND v(dout0_14) AT=1790.05n

.meas tran vdout0_15ck1780 FIND v(dout0_15) AT=1790.05n

.meas tran vdout0_16ck1780 FIND v(dout0_16) AT=1790.05n

.meas tran vdout0_17ck1780 FIND v(dout0_17) AT=1790.05n

.meas tran vdout0_18ck1780 FIND v(dout0_18) AT=1790.05n

.meas tran vdout0_19ck1780 FIND v(dout0_19) AT=1790.05n

.meas tran vdout0_20ck1780 FIND v(dout0_20) AT=1790.05n

.meas tran vdout0_21ck1780 FIND v(dout0_21) AT=1790.05n

.meas tran vdout0_22ck1780 FIND v(dout0_22) AT=1790.05n

.meas tran vdout0_23ck1780 FIND v(dout0_23) AT=1790.05n

.meas tran vdout0_24ck1780 FIND v(dout0_24) AT=1790.05n

.meas tran vdout0_25ck1780 FIND v(dout0_25) AT=1790.05n

.meas tran vdout0_26ck1780 FIND v(dout0_26) AT=1790.05n

.meas tran vdout0_27ck1780 FIND v(dout0_27) AT=1790.05n

.meas tran vdout0_28ck1780 FIND v(dout0_28) AT=1790.05n

.meas tran vdout0_29ck1780 FIND v(dout0_29) AT=1790.05n

.meas tran vdout0_30ck1780 FIND v(dout0_30) AT=1790.05n

.meas tran vdout0_31ck1780 FIND v(dout0_31) AT=1790.05n

.meas tran vdout0_32ck1780 FIND v(dout0_32) AT=1790.05n

.meas tran vdout0_0ck1820 FIND v(dout0_0) AT=1830.05n

.meas tran vdout0_1ck1820 FIND v(dout0_1) AT=1830.05n

.meas tran vdout0_2ck1820 FIND v(dout0_2) AT=1830.05n

.meas tran vdout0_3ck1820 FIND v(dout0_3) AT=1830.05n

.meas tran vdout0_4ck1820 FIND v(dout0_4) AT=1830.05n

.meas tran vdout0_5ck1820 FIND v(dout0_5) AT=1830.05n

.meas tran vdout0_6ck1820 FIND v(dout0_6) AT=1830.05n

.meas tran vdout0_7ck1820 FIND v(dout0_7) AT=1830.05n

.meas tran vdout0_8ck1820 FIND v(dout0_8) AT=1830.05n

.meas tran vdout0_9ck1820 FIND v(dout0_9) AT=1830.05n

.meas tran vdout0_10ck1820 FIND v(dout0_10) AT=1830.05n

.meas tran vdout0_11ck1820 FIND v(dout0_11) AT=1830.05n

.meas tran vdout0_12ck1820 FIND v(dout0_12) AT=1830.05n

.meas tran vdout0_13ck1820 FIND v(dout0_13) AT=1830.05n

.meas tran vdout0_14ck1820 FIND v(dout0_14) AT=1830.05n

.meas tran vdout0_15ck1820 FIND v(dout0_15) AT=1830.05n

.meas tran vdout0_16ck1820 FIND v(dout0_16) AT=1830.05n

.meas tran vdout0_17ck1820 FIND v(dout0_17) AT=1830.05n

.meas tran vdout0_18ck1820 FIND v(dout0_18) AT=1830.05n

.meas tran vdout0_19ck1820 FIND v(dout0_19) AT=1830.05n

.meas tran vdout0_20ck1820 FIND v(dout0_20) AT=1830.05n

.meas tran vdout0_21ck1820 FIND v(dout0_21) AT=1830.05n

.meas tran vdout0_22ck1820 FIND v(dout0_22) AT=1830.05n

.meas tran vdout0_23ck1820 FIND v(dout0_23) AT=1830.05n

.meas tran vdout0_24ck1820 FIND v(dout0_24) AT=1830.05n

.meas tran vdout0_25ck1820 FIND v(dout0_25) AT=1830.05n

.meas tran vdout0_26ck1820 FIND v(dout0_26) AT=1830.05n

.meas tran vdout0_27ck1820 FIND v(dout0_27) AT=1830.05n

.meas tran vdout0_28ck1820 FIND v(dout0_28) AT=1830.05n

.meas tran vdout0_29ck1820 FIND v(dout0_29) AT=1830.05n

.meas tran vdout0_30ck1820 FIND v(dout0_30) AT=1830.05n

.meas tran vdout0_31ck1820 FIND v(dout0_31) AT=1830.05n

.meas tran vdout0_32ck1820 FIND v(dout0_32) AT=1830.05n

.meas tran vdout0_0ck1910 FIND v(dout0_0) AT=1920.05n

.meas tran vdout0_1ck1910 FIND v(dout0_1) AT=1920.05n

.meas tran vdout0_2ck1910 FIND v(dout0_2) AT=1920.05n

.meas tran vdout0_3ck1910 FIND v(dout0_3) AT=1920.05n

.meas tran vdout0_4ck1910 FIND v(dout0_4) AT=1920.05n

.meas tran vdout0_5ck1910 FIND v(dout0_5) AT=1920.05n

.meas tran vdout0_6ck1910 FIND v(dout0_6) AT=1920.05n

.meas tran vdout0_7ck1910 FIND v(dout0_7) AT=1920.05n

.meas tran vdout0_8ck1910 FIND v(dout0_8) AT=1920.05n

.meas tran vdout0_9ck1910 FIND v(dout0_9) AT=1920.05n

.meas tran vdout0_10ck1910 FIND v(dout0_10) AT=1920.05n

.meas tran vdout0_11ck1910 FIND v(dout0_11) AT=1920.05n

.meas tran vdout0_12ck1910 FIND v(dout0_12) AT=1920.05n

.meas tran vdout0_13ck1910 FIND v(dout0_13) AT=1920.05n

.meas tran vdout0_14ck1910 FIND v(dout0_14) AT=1920.05n

.meas tran vdout0_15ck1910 FIND v(dout0_15) AT=1920.05n

.meas tran vdout0_16ck1910 FIND v(dout0_16) AT=1920.05n

.meas tran vdout0_17ck1910 FIND v(dout0_17) AT=1920.05n

.meas tran vdout0_18ck1910 FIND v(dout0_18) AT=1920.05n

.meas tran vdout0_19ck1910 FIND v(dout0_19) AT=1920.05n

.meas tran vdout0_20ck1910 FIND v(dout0_20) AT=1920.05n

.meas tran vdout0_21ck1910 FIND v(dout0_21) AT=1920.05n

.meas tran vdout0_22ck1910 FIND v(dout0_22) AT=1920.05n

.meas tran vdout0_23ck1910 FIND v(dout0_23) AT=1920.05n

.meas tran vdout0_24ck1910 FIND v(dout0_24) AT=1920.05n

.meas tran vdout0_25ck1910 FIND v(dout0_25) AT=1920.05n

.meas tran vdout0_26ck1910 FIND v(dout0_26) AT=1920.05n

.meas tran vdout0_27ck1910 FIND v(dout0_27) AT=1920.05n

.meas tran vdout0_28ck1910 FIND v(dout0_28) AT=1920.05n

.meas tran vdout0_29ck1910 FIND v(dout0_29) AT=1920.05n

.meas tran vdout0_30ck1910 FIND v(dout0_30) AT=1920.05n

.meas tran vdout0_31ck1910 FIND v(dout0_31) AT=1920.05n

.meas tran vdout0_32ck1910 FIND v(dout0_32) AT=1920.05n

.meas tran vdout0_0ck1920 FIND v(dout0_0) AT=1930.05n

.meas tran vdout0_1ck1920 FIND v(dout0_1) AT=1930.05n

.meas tran vdout0_2ck1920 FIND v(dout0_2) AT=1930.05n

.meas tran vdout0_3ck1920 FIND v(dout0_3) AT=1930.05n

.meas tran vdout0_4ck1920 FIND v(dout0_4) AT=1930.05n

.meas tran vdout0_5ck1920 FIND v(dout0_5) AT=1930.05n

.meas tran vdout0_6ck1920 FIND v(dout0_6) AT=1930.05n

.meas tran vdout0_7ck1920 FIND v(dout0_7) AT=1930.05n

.meas tran vdout0_8ck1920 FIND v(dout0_8) AT=1930.05n

.meas tran vdout0_9ck1920 FIND v(dout0_9) AT=1930.05n

.meas tran vdout0_10ck1920 FIND v(dout0_10) AT=1930.05n

.meas tran vdout0_11ck1920 FIND v(dout0_11) AT=1930.05n

.meas tran vdout0_12ck1920 FIND v(dout0_12) AT=1930.05n

.meas tran vdout0_13ck1920 FIND v(dout0_13) AT=1930.05n

.meas tran vdout0_14ck1920 FIND v(dout0_14) AT=1930.05n

.meas tran vdout0_15ck1920 FIND v(dout0_15) AT=1930.05n

.meas tran vdout0_16ck1920 FIND v(dout0_16) AT=1930.05n

.meas tran vdout0_17ck1920 FIND v(dout0_17) AT=1930.05n

.meas tran vdout0_18ck1920 FIND v(dout0_18) AT=1930.05n

.meas tran vdout0_19ck1920 FIND v(dout0_19) AT=1930.05n

.meas tran vdout0_20ck1920 FIND v(dout0_20) AT=1930.05n

.meas tran vdout0_21ck1920 FIND v(dout0_21) AT=1930.05n

.meas tran vdout0_22ck1920 FIND v(dout0_22) AT=1930.05n

.meas tran vdout0_23ck1920 FIND v(dout0_23) AT=1930.05n

.meas tran vdout0_24ck1920 FIND v(dout0_24) AT=1930.05n

.meas tran vdout0_25ck1920 FIND v(dout0_25) AT=1930.05n

.meas tran vdout0_26ck1920 FIND v(dout0_26) AT=1930.05n

.meas tran vdout0_27ck1920 FIND v(dout0_27) AT=1930.05n

.meas tran vdout0_28ck1920 FIND v(dout0_28) AT=1930.05n

.meas tran vdout0_29ck1920 FIND v(dout0_29) AT=1930.05n

.meas tran vdout0_30ck1920 FIND v(dout0_30) AT=1930.05n

.meas tran vdout0_31ck1920 FIND v(dout0_31) AT=1930.05n

.meas tran vdout0_32ck1920 FIND v(dout0_32) AT=1930.05n

.meas tran vdout0_0ck2020 FIND v(dout0_0) AT=2030.05n

.meas tran vdout0_1ck2020 FIND v(dout0_1) AT=2030.05n

.meas tran vdout0_2ck2020 FIND v(dout0_2) AT=2030.05n

.meas tran vdout0_3ck2020 FIND v(dout0_3) AT=2030.05n

.meas tran vdout0_4ck2020 FIND v(dout0_4) AT=2030.05n

.meas tran vdout0_5ck2020 FIND v(dout0_5) AT=2030.05n

.meas tran vdout0_6ck2020 FIND v(dout0_6) AT=2030.05n

.meas tran vdout0_7ck2020 FIND v(dout0_7) AT=2030.05n

.meas tran vdout0_8ck2020 FIND v(dout0_8) AT=2030.05n

.meas tran vdout0_9ck2020 FIND v(dout0_9) AT=2030.05n

.meas tran vdout0_10ck2020 FIND v(dout0_10) AT=2030.05n

.meas tran vdout0_11ck2020 FIND v(dout0_11) AT=2030.05n

.meas tran vdout0_12ck2020 FIND v(dout0_12) AT=2030.05n

.meas tran vdout0_13ck2020 FIND v(dout0_13) AT=2030.05n

.meas tran vdout0_14ck2020 FIND v(dout0_14) AT=2030.05n

.meas tran vdout0_15ck2020 FIND v(dout0_15) AT=2030.05n

.meas tran vdout0_16ck2020 FIND v(dout0_16) AT=2030.05n

.meas tran vdout0_17ck2020 FIND v(dout0_17) AT=2030.05n

.meas tran vdout0_18ck2020 FIND v(dout0_18) AT=2030.05n

.meas tran vdout0_19ck2020 FIND v(dout0_19) AT=2030.05n

.meas tran vdout0_20ck2020 FIND v(dout0_20) AT=2030.05n

.meas tran vdout0_21ck2020 FIND v(dout0_21) AT=2030.05n

.meas tran vdout0_22ck2020 FIND v(dout0_22) AT=2030.05n

.meas tran vdout0_23ck2020 FIND v(dout0_23) AT=2030.05n

.meas tran vdout0_24ck2020 FIND v(dout0_24) AT=2030.05n

.meas tran vdout0_25ck2020 FIND v(dout0_25) AT=2030.05n

.meas tran vdout0_26ck2020 FIND v(dout0_26) AT=2030.05n

.meas tran vdout0_27ck2020 FIND v(dout0_27) AT=2030.05n

.meas tran vdout0_28ck2020 FIND v(dout0_28) AT=2030.05n

.meas tran vdout0_29ck2020 FIND v(dout0_29) AT=2030.05n

.meas tran vdout0_30ck2020 FIND v(dout0_30) AT=2030.05n

.meas tran vdout0_31ck2020 FIND v(dout0_31) AT=2030.05n

.meas tran vdout0_32ck2020 FIND v(dout0_32) AT=2030.05n

.meas tran vdout0_0ck2030 FIND v(dout0_0) AT=2040.05n

.meas tran vdout0_1ck2030 FIND v(dout0_1) AT=2040.05n

.meas tran vdout0_2ck2030 FIND v(dout0_2) AT=2040.05n

.meas tran vdout0_3ck2030 FIND v(dout0_3) AT=2040.05n

.meas tran vdout0_4ck2030 FIND v(dout0_4) AT=2040.05n

.meas tran vdout0_5ck2030 FIND v(dout0_5) AT=2040.05n

.meas tran vdout0_6ck2030 FIND v(dout0_6) AT=2040.05n

.meas tran vdout0_7ck2030 FIND v(dout0_7) AT=2040.05n

.meas tran vdout0_8ck2030 FIND v(dout0_8) AT=2040.05n

.meas tran vdout0_9ck2030 FIND v(dout0_9) AT=2040.05n

.meas tran vdout0_10ck2030 FIND v(dout0_10) AT=2040.05n

.meas tran vdout0_11ck2030 FIND v(dout0_11) AT=2040.05n

.meas tran vdout0_12ck2030 FIND v(dout0_12) AT=2040.05n

.meas tran vdout0_13ck2030 FIND v(dout0_13) AT=2040.05n

.meas tran vdout0_14ck2030 FIND v(dout0_14) AT=2040.05n

.meas tran vdout0_15ck2030 FIND v(dout0_15) AT=2040.05n

.meas tran vdout0_16ck2030 FIND v(dout0_16) AT=2040.05n

.meas tran vdout0_17ck2030 FIND v(dout0_17) AT=2040.05n

.meas tran vdout0_18ck2030 FIND v(dout0_18) AT=2040.05n

.meas tran vdout0_19ck2030 FIND v(dout0_19) AT=2040.05n

.meas tran vdout0_20ck2030 FIND v(dout0_20) AT=2040.05n

.meas tran vdout0_21ck2030 FIND v(dout0_21) AT=2040.05n

.meas tran vdout0_22ck2030 FIND v(dout0_22) AT=2040.05n

.meas tran vdout0_23ck2030 FIND v(dout0_23) AT=2040.05n

.meas tran vdout0_24ck2030 FIND v(dout0_24) AT=2040.05n

.meas tran vdout0_25ck2030 FIND v(dout0_25) AT=2040.05n

.meas tran vdout0_26ck2030 FIND v(dout0_26) AT=2040.05n

.meas tran vdout0_27ck2030 FIND v(dout0_27) AT=2040.05n

.meas tran vdout0_28ck2030 FIND v(dout0_28) AT=2040.05n

.meas tran vdout0_29ck2030 FIND v(dout0_29) AT=2040.05n

.meas tran vdout0_30ck2030 FIND v(dout0_30) AT=2040.05n

.meas tran vdout0_31ck2030 FIND v(dout0_31) AT=2040.05n

.meas tran vdout0_32ck2030 FIND v(dout0_32) AT=2040.05n
